* Extracted by KLayout with SG13G2 LVS runset on : 08/09/2026 00:25

.SUBCKT tt_analog_ring VGND VPWR b1 clk_out code[0] code[1] code[2] code[3]
+ code[4] code[5] code[6] code[7] enable s0 s1 s10 s2 s3 s4 s5 s6 s7 s8 s9 vbn
+ vbp
M$1 VGND code[0] vbp VGND sg13_lv_nmos L=8u W=0.15u AS=0.1005p AD=0.1005p
+ PS=1.34u PD=1.34u rfmode=0
M$2 VGND code[1] vbp VGND sg13_lv_nmos L=8u W=0.15u AS=0.1005p AD=0.0555p
+ PS=1.34u PD=0.74u rfmode=0
M$3 vbp code[1] VGND VGND sg13_lv_nmos L=8u W=0.15u AS=0.0555p AD=0.1005p
+ PS=0.74u PD=1.34u rfmode=0
M$4 VGND VPWR vbp VGND sg13_lv_nmos L=8u W=0.15u AS=0.1005p AD=0.0555p PS=1.34u
+ PD=0.74u rfmode=0
M$5 vbp VPWR VGND VGND sg13_lv_nmos L=8u W=0.15u AS=0.0555p AD=0.1005p PS=0.74u
+ PD=1.34u rfmode=0
M$6 VPWR b1 clk_out VPWR sg13_lv_pmos L=0.13u W=2u AS=0.68p AD=0.68p PS=4.68u
+ PD=4.68u rfmode=0
M$7 VGND b1 clk_out VGND sg13_lv_nmos L=0.13u W=1u AS=0.34p AD=0.34p PS=2.68u
+ PD=2.68u rfmode=0
M$8 \$126 s2 s3 VPWR sg13_lv_pmos L=0.13u W=0.5u AS=0.17p AD=0.17p PS=1.68u
+ PD=1.68u rfmode=0
M$9 \$125 s1 s2 VPWR sg13_lv_pmos L=0.13u W=0.5u AS=0.17p AD=0.17p PS=1.68u
+ PD=1.68u rfmode=0
M$10 VPWR s10 b1 VPWR sg13_lv_pmos L=0.13u W=0.5u AS=0.17p AD=0.17p PS=1.68u
+ PD=1.68u rfmode=0
M$11 \$128 s5 s6 VPWR sg13_lv_pmos L=0.13u W=0.5u AS=0.17p AD=0.17p PS=1.68u
+ PD=1.68u rfmode=0
M$12 \$133 s9 s10 VPWR sg13_lv_pmos L=0.13u W=0.5u AS=0.17p AD=0.17p PS=1.68u
+ PD=1.68u rfmode=0
M$13 \$129 s4 s5 VPWR sg13_lv_pmos L=0.13u W=0.5u AS=0.17p AD=0.17p PS=1.68u
+ PD=1.68u rfmode=0
M$14 \$132 s8 s9 VPWR sg13_lv_pmos L=0.13u W=0.5u AS=0.17p AD=0.17p PS=1.68u
+ PD=1.68u rfmode=0
M$15 \$130 s6 s7 VPWR sg13_lv_pmos L=0.13u W=0.5u AS=0.17p AD=0.17p PS=1.68u
+ PD=1.68u rfmode=0
M$16 \$127 s3 s4 VPWR sg13_lv_pmos L=0.13u W=0.5u AS=0.17p AD=0.17p PS=1.68u
+ PD=1.68u rfmode=0
M$17 \$131 s7 s8 VPWR sg13_lv_pmos L=0.13u W=0.5u AS=0.17p AD=0.17p PS=1.68u
+ PD=1.68u rfmode=0
M$18 \$124 s0 s1 VPWR sg13_lv_pmos L=0.13u W=0.5u AS=0.17p AD=0.17p PS=1.68u
+ PD=1.68u rfmode=0
M$19 \$71 s0 s1 VGND sg13_lv_nmos L=0.13u W=0.3u AS=0.102p AD=0.102p PS=1.28u
+ PD=1.28u rfmode=0
M$20 VGND s10 b1 VGND sg13_lv_nmos L=0.13u W=0.3u AS=0.102p AD=0.102p PS=1.28u
+ PD=1.28u rfmode=0
M$21 \$72 s6 s7 VGND sg13_lv_nmos L=0.13u W=0.3u AS=0.102p AD=0.102p PS=1.28u
+ PD=1.28u rfmode=0
M$22 \$70 s7 s8 VGND sg13_lv_nmos L=0.13u W=0.3u AS=0.102p AD=0.102p PS=1.28u
+ PD=1.28u rfmode=0
M$23 \$77 s2 s3 VGND sg13_lv_nmos L=0.13u W=0.3u AS=0.102p AD=0.102p PS=1.28u
+ PD=1.28u rfmode=0
M$24 \$75 s1 s2 VGND sg13_lv_nmos L=0.13u W=0.3u AS=0.102p AD=0.102p PS=1.28u
+ PD=1.28u rfmode=0
M$25 \$73 s5 s6 VGND sg13_lv_nmos L=0.13u W=0.3u AS=0.102p AD=0.102p PS=1.28u
+ PD=1.28u rfmode=0
M$26 \$67 s9 s10 VGND sg13_lv_nmos L=0.13u W=0.3u AS=0.102p AD=0.102p PS=1.28u
+ PD=1.28u rfmode=0
M$27 \$76 s3 s4 VGND sg13_lv_nmos L=0.13u W=0.3u AS=0.102p AD=0.102p PS=1.28u
+ PD=1.28u rfmode=0
M$28 \$69 s8 s9 VGND sg13_lv_nmos L=0.13u W=0.3u AS=0.102p AD=0.102p PS=1.28u
+ PD=1.28u rfmode=0
M$29 \$74 s4 s5 VGND sg13_lv_nmos L=0.13u W=0.3u AS=0.102p AD=0.102p PS=1.28u
+ PD=1.28u rfmode=0
M$30 \$122 enable s0 VPWR sg13_lv_pmos L=0.13u W=0.5u AS=0.17p AD=0.095p
+ PS=1.68u PD=0.88u rfmode=0
M$31 s0 s10 \$122 VPWR sg13_lv_pmos L=0.13u W=0.5u AS=0.095p AD=0.17p PS=0.88u
+ PD=1.68u rfmode=0
M$32 \$68 enable \$I1005 VGND sg13_lv_nmos L=0.13u W=0.6u AS=0.204p AD=0.114p
+ PS=1.88u PD=0.98u rfmode=0
M$33 \$I1005 s10 s0 VGND sg13_lv_nmos L=0.13u W=0.6u AS=0.114p AD=0.204p
+ PS=0.98u PD=1.88u rfmode=0
M$34 VGND vbn vbn VGND sg13_lv_nmos L=0.5u W=0.5u AS=0.17p AD=0.17p PS=1.68u
+ PD=1.68u rfmode=0
M$35 VGND vbn \$72 VGND sg13_lv_nmos L=0.5u W=0.5u AS=0.17p AD=0.17p PS=1.68u
+ PD=1.68u rfmode=0
M$36 VGND vbn \$77 VGND sg13_lv_nmos L=0.5u W=0.5u AS=0.17p AD=0.17p PS=1.68u
+ PD=1.68u rfmode=0
M$37 VGND vbn \$68 VGND sg13_lv_nmos L=0.5u W=0.5u AS=0.17p AD=0.17p PS=1.68u
+ PD=1.68u rfmode=0
M$38 VGND vbn \$75 VGND sg13_lv_nmos L=0.5u W=0.5u AS=0.17p AD=0.17p PS=1.68u
+ PD=1.68u rfmode=0
M$39 VGND vbn \$73 VGND sg13_lv_nmos L=0.5u W=0.5u AS=0.17p AD=0.17p PS=1.68u
+ PD=1.68u rfmode=0
M$40 VGND vbn \$69 VGND sg13_lv_nmos L=0.5u W=0.5u AS=0.17p AD=0.17p PS=1.68u
+ PD=1.68u rfmode=0
M$41 VGND vbn \$76 VGND sg13_lv_nmos L=0.5u W=0.5u AS=0.17p AD=0.17p PS=1.68u
+ PD=1.68u rfmode=0
M$42 VGND vbn \$67 VGND sg13_lv_nmos L=0.5u W=0.5u AS=0.17p AD=0.17p PS=1.68u
+ PD=1.68u rfmode=0
M$43 VGND vbn \$71 VGND sg13_lv_nmos L=0.5u W=0.5u AS=0.17p AD=0.17p PS=1.68u
+ PD=1.68u rfmode=0
M$44 VGND vbn \$74 VGND sg13_lv_nmos L=0.5u W=0.5u AS=0.17p AD=0.17p PS=1.68u
+ PD=1.68u rfmode=0
M$45 VGND vbn \$70 VGND sg13_lv_nmos L=0.5u W=0.5u AS=0.17p AD=0.17p PS=1.68u
+ PD=1.68u rfmode=0
M$46 VPWR vbp vbn VPWR sg13_lv_pmos L=0.5u W=1u AS=0.34p AD=0.34p PS=2.68u
+ PD=2.68u rfmode=0
M$47 VPWR vbp \$130 VPWR sg13_lv_pmos L=0.5u W=1u AS=0.34p AD=0.34p PS=2.68u
+ PD=2.68u rfmode=0
M$48 VPWR vbp \$122 VPWR sg13_lv_pmos L=0.5u W=1u AS=0.34p AD=0.34p PS=2.68u
+ PD=2.68u rfmode=0
M$49 VPWR vbp \$128 VPWR sg13_lv_pmos L=0.5u W=1u AS=0.34p AD=0.34p PS=2.68u
+ PD=2.68u rfmode=0
M$50 VPWR vbp \$125 VPWR sg13_lv_pmos L=0.5u W=1u AS=0.34p AD=0.34p PS=2.68u
+ PD=2.68u rfmode=0
M$51 VPWR vbp \$124 VPWR sg13_lv_pmos L=0.5u W=1u AS=0.34p AD=0.34p PS=2.68u
+ PD=2.68u rfmode=0
M$52 VPWR vbp \$127 VPWR sg13_lv_pmos L=0.5u W=1u AS=0.34p AD=0.34p PS=2.68u
+ PD=2.68u rfmode=0
M$53 VPWR vbp \$126 VPWR sg13_lv_pmos L=0.5u W=1u AS=0.34p AD=0.34p PS=2.68u
+ PD=2.68u rfmode=0
M$54 VPWR vbp \$132 VPWR sg13_lv_pmos L=0.5u W=1u AS=0.34p AD=0.34p PS=2.68u
+ PD=2.68u rfmode=0
M$55 VPWR vbp \$129 VPWR sg13_lv_pmos L=0.5u W=1u AS=0.34p AD=0.34p PS=2.68u
+ PD=2.68u rfmode=0
M$56 VPWR vbp \$133 VPWR sg13_lv_pmos L=0.5u W=1u AS=0.34p AD=0.34p PS=2.68u
+ PD=2.68u rfmode=0
M$57 VPWR vbp \$131 VPWR sg13_lv_pmos L=0.5u W=1u AS=0.34p AD=0.34p PS=2.68u
+ PD=2.68u rfmode=0
M$58 VPWR vbp vbp VPWR sg13_lv_pmos L=0.5u W=2u AS=0.68p AD=0.38p PS=4.68u
+ PD=2.38u rfmode=0
M$59 vbp vbp VPWR VPWR sg13_lv_pmos L=0.5u W=2u AS=0.38p AD=0.38p PS=2.38u
+ PD=2.38u rfmode=0
M$60 VPWR vbp vbp VPWR sg13_lv_pmos L=0.5u W=2u AS=0.38p AD=0.38p PS=2.38u
+ PD=2.38u rfmode=0
M$61 vbp vbp VPWR VPWR sg13_lv_pmos L=0.5u W=2u AS=0.38p AD=0.38p PS=2.38u
+ PD=2.38u rfmode=0
M$62 VPWR vbp vbp VPWR sg13_lv_pmos L=0.5u W=2u AS=0.38p AD=0.38p PS=2.38u
+ PD=2.38u rfmode=0
M$63 vbp vbp VPWR VPWR sg13_lv_pmos L=0.5u W=2u AS=0.38p AD=0.38p PS=2.38u
+ PD=2.38u rfmode=0
M$64 VPWR vbp vbp VPWR sg13_lv_pmos L=0.5u W=2u AS=0.38p AD=0.38p PS=2.38u
+ PD=2.38u rfmode=0
M$65 vbp vbp VPWR VPWR sg13_lv_pmos L=0.5u W=2u AS=0.38p AD=0.38p PS=2.38u
+ PD=2.38u rfmode=0
M$66 VPWR vbp vbp VPWR sg13_lv_pmos L=0.5u W=2u AS=0.38p AD=0.38p PS=2.38u
+ PD=2.38u rfmode=0
M$67 vbp vbp VPWR VPWR sg13_lv_pmos L=0.5u W=2u AS=0.38p AD=0.38p PS=2.38u
+ PD=2.38u rfmode=0
M$68 VPWR vbp vbp VPWR sg13_lv_pmos L=0.5u W=2u AS=0.38p AD=0.38p PS=2.38u
+ PD=2.38u rfmode=0
M$69 vbp vbp VPWR VPWR sg13_lv_pmos L=0.5u W=2u AS=0.38p AD=0.38p PS=2.38u
+ PD=2.38u rfmode=0
M$70 VPWR vbp vbp VPWR sg13_lv_pmos L=0.5u W=2u AS=0.38p AD=0.38p PS=2.38u
+ PD=2.38u rfmode=0
M$71 vbp vbp VPWR VPWR sg13_lv_pmos L=0.5u W=2u AS=0.38p AD=0.38p PS=2.38u
+ PD=2.38u rfmode=0
M$72 VPWR vbp vbp VPWR sg13_lv_pmos L=0.5u W=2u AS=0.38p AD=0.38p PS=2.38u
+ PD=2.38u rfmode=0
M$73 vbp vbp VPWR VPWR sg13_lv_pmos L=0.5u W=2u AS=0.38p AD=0.38p PS=2.38u
+ PD=2.38u rfmode=0
M$74 VPWR vbp vbp VPWR sg13_lv_pmos L=0.5u W=2u AS=0.38p AD=0.38p PS=2.38u
+ PD=2.38u rfmode=0
M$75 vbp vbp VPWR VPWR sg13_lv_pmos L=0.5u W=2u AS=0.38p AD=0.38p PS=2.38u
+ PD=2.38u rfmode=0
M$76 VPWR vbp vbp VPWR sg13_lv_pmos L=0.5u W=2u AS=0.38p AD=0.38p PS=2.38u
+ PD=2.38u rfmode=0
M$77 vbp vbp VPWR VPWR sg13_lv_pmos L=0.5u W=2u AS=0.38p AD=0.38p PS=2.38u
+ PD=2.38u rfmode=0
M$78 VPWR vbp vbp VPWR sg13_lv_pmos L=0.5u W=2u AS=0.38p AD=0.38p PS=2.38u
+ PD=2.38u rfmode=0
M$79 vbp vbp VPWR VPWR sg13_lv_pmos L=0.5u W=2u AS=0.38p AD=0.38p PS=2.38u
+ PD=2.38u rfmode=0
M$80 VPWR vbp vbp VPWR sg13_lv_pmos L=0.5u W=2u AS=0.38p AD=0.38p PS=2.38u
+ PD=2.38u rfmode=0
M$81 vbp vbp VPWR VPWR sg13_lv_pmos L=0.5u W=2u AS=0.38p AD=0.68p PS=2.38u
+ PD=4.68u rfmode=0
M$82 VGND code[7] vbp VGND sg13_lv_nmos L=8u W=0.15u AS=0.1005p AD=0.0555p
+ PS=1.34u PD=0.74u rfmode=0
M$83 vbp code[7] VGND VGND sg13_lv_nmos L=8u W=0.15u AS=0.0555p AD=0.0555p
+ PS=0.74u PD=0.74u rfmode=0
M$84 VGND code[7] vbp VGND sg13_lv_nmos L=8u W=0.15u AS=0.0555p AD=0.0555p
+ PS=0.74u PD=0.74u rfmode=0
M$85 vbp code[7] VGND VGND sg13_lv_nmos L=8u W=0.15u AS=0.0555p AD=0.1005p
+ PS=0.74u PD=1.34u rfmode=0
M$86 VGND code[6] vbp VGND sg13_lv_nmos L=8u W=0.15u AS=0.1005p AD=0.0555p
+ PS=1.34u PD=0.74u rfmode=0
M$87 vbp code[6] VGND VGND sg13_lv_nmos L=8u W=0.15u AS=0.0555p AD=0.0555p
+ PS=0.74u PD=0.74u rfmode=0
M$88 VGND code[6] vbp VGND sg13_lv_nmos L=8u W=0.15u AS=0.0555p AD=0.0555p
+ PS=0.74u PD=0.74u rfmode=0
M$89 vbp code[6] VGND VGND sg13_lv_nmos L=8u W=0.15u AS=0.0555p AD=0.1005p
+ PS=0.74u PD=1.34u rfmode=0
M$90 VGND code[5] vbp VGND sg13_lv_nmos L=8u W=0.15u AS=0.1005p AD=0.0555p
+ PS=1.34u PD=0.74u rfmode=0
M$91 vbp code[5] VGND VGND sg13_lv_nmos L=8u W=0.15u AS=0.0555p AD=0.0555p
+ PS=0.74u PD=0.74u rfmode=0
M$92 VGND code[5] vbp VGND sg13_lv_nmos L=8u W=0.15u AS=0.0555p AD=0.0555p
+ PS=0.74u PD=0.74u rfmode=0
M$93 vbp code[5] VGND VGND sg13_lv_nmos L=8u W=0.15u AS=0.0555p AD=0.1005p
+ PS=0.74u PD=1.34u rfmode=0
M$94 VGND code[5] vbp VGND sg13_lv_nmos L=8u W=0.15u AS=0.1005p AD=0.0555p
+ PS=1.34u PD=0.74u rfmode=0
M$95 vbp code[5] VGND VGND sg13_lv_nmos L=8u W=0.15u AS=0.0555p AD=0.0555p
+ PS=0.74u PD=0.74u rfmode=0
M$96 VGND code[5] vbp VGND sg13_lv_nmos L=8u W=0.15u AS=0.0555p AD=0.0555p
+ PS=0.74u PD=0.74u rfmode=0
M$97 vbp code[5] VGND VGND sg13_lv_nmos L=8u W=0.15u AS=0.0555p AD=0.1005p
+ PS=0.74u PD=1.34u rfmode=0
M$98 VGND code[5] vbp VGND sg13_lv_nmos L=8u W=0.15u AS=0.1005p AD=0.0555p
+ PS=1.34u PD=0.74u rfmode=0
M$99 vbp code[5] VGND VGND sg13_lv_nmos L=8u W=0.15u AS=0.0555p AD=0.0555p
+ PS=0.74u PD=0.74u rfmode=0
M$100 VGND code[5] vbp VGND sg13_lv_nmos L=8u W=0.15u AS=0.0555p AD=0.0555p
+ PS=0.74u PD=0.74u rfmode=0
M$101 vbp code[5] VGND VGND sg13_lv_nmos L=8u W=0.15u AS=0.0555p AD=0.1005p
+ PS=0.74u PD=1.34u rfmode=0
M$102 VGND code[5] vbp VGND sg13_lv_nmos L=8u W=0.15u AS=0.1005p AD=0.0555p
+ PS=1.34u PD=0.74u rfmode=0
M$103 vbp code[5] VGND VGND sg13_lv_nmos L=8u W=0.15u AS=0.0555p AD=0.0555p
+ PS=0.74u PD=0.74u rfmode=0
M$104 VGND code[5] vbp VGND sg13_lv_nmos L=8u W=0.15u AS=0.0555p AD=0.0555p
+ PS=0.74u PD=0.74u rfmode=0
M$105 vbp code[5] VGND VGND sg13_lv_nmos L=8u W=0.15u AS=0.0555p AD=0.1005p
+ PS=0.74u PD=1.34u rfmode=0
M$106 VGND code[4] vbp VGND sg13_lv_nmos L=8u W=0.15u AS=0.1005p AD=0.0555p
+ PS=1.34u PD=0.74u rfmode=0
M$107 vbp code[4] VGND VGND sg13_lv_nmos L=8u W=0.15u AS=0.0555p AD=0.0555p
+ PS=0.74u PD=0.74u rfmode=0
M$108 VGND code[4] vbp VGND sg13_lv_nmos L=8u W=0.15u AS=0.0555p AD=0.0555p
+ PS=0.74u PD=0.74u rfmode=0
M$109 vbp code[4] VGND VGND sg13_lv_nmos L=8u W=0.15u AS=0.0555p AD=0.1005p
+ PS=0.74u PD=1.34u rfmode=0
M$110 VGND code[4] vbp VGND sg13_lv_nmos L=8u W=0.15u AS=0.1005p AD=0.0555p
+ PS=1.34u PD=0.74u rfmode=0
M$111 vbp code[4] VGND VGND sg13_lv_nmos L=8u W=0.15u AS=0.0555p AD=0.0555p
+ PS=0.74u PD=0.74u rfmode=0
M$112 VGND code[4] vbp VGND sg13_lv_nmos L=8u W=0.15u AS=0.0555p AD=0.0555p
+ PS=0.74u PD=0.74u rfmode=0
M$113 vbp code[4] VGND VGND sg13_lv_nmos L=8u W=0.15u AS=0.0555p AD=0.1005p
+ PS=0.74u PD=1.34u rfmode=0
M$114 VGND code[3] vbp VGND sg13_lv_nmos L=8u W=0.15u AS=0.1005p AD=0.0555p
+ PS=1.34u PD=0.74u rfmode=0
M$115 vbp code[3] VGND VGND sg13_lv_nmos L=8u W=0.15u AS=0.0555p AD=0.0555p
+ PS=0.74u PD=0.74u rfmode=0
M$116 VGND code[3] vbp VGND sg13_lv_nmos L=8u W=0.15u AS=0.0555p AD=0.0555p
+ PS=0.74u PD=0.74u rfmode=0
M$117 vbp code[3] VGND VGND sg13_lv_nmos L=8u W=0.15u AS=0.0555p AD=0.1005p
+ PS=0.74u PD=1.34u rfmode=0
M$118 VGND code[6] vbp VGND sg13_lv_nmos L=8u W=0.15u AS=0.1005p AD=0.0555p
+ PS=1.34u PD=0.74u rfmode=0
M$119 vbp code[6] VGND VGND sg13_lv_nmos L=8u W=0.15u AS=0.0555p AD=0.0555p
+ PS=0.74u PD=0.74u rfmode=0
M$120 VGND code[6] vbp VGND sg13_lv_nmos L=8u W=0.15u AS=0.0555p AD=0.0555p
+ PS=0.74u PD=0.74u rfmode=0
M$121 vbp code[6] VGND VGND sg13_lv_nmos L=8u W=0.15u AS=0.0555p AD=0.1005p
+ PS=0.74u PD=1.34u rfmode=0
M$122 VGND code[7] vbp VGND sg13_lv_nmos L=8u W=0.15u AS=0.1005p AD=0.0555p
+ PS=1.34u PD=0.74u rfmode=0
M$123 vbp code[7] VGND VGND sg13_lv_nmos L=8u W=0.15u AS=0.0555p AD=0.0555p
+ PS=0.74u PD=0.74u rfmode=0
M$124 VGND code[7] vbp VGND sg13_lv_nmos L=8u W=0.15u AS=0.0555p AD=0.0555p
+ PS=0.74u PD=0.74u rfmode=0
M$125 vbp code[7] VGND VGND sg13_lv_nmos L=8u W=0.15u AS=0.0555p AD=0.1005p
+ PS=0.74u PD=1.34u rfmode=0
M$126 VGND code[7] vbp VGND sg13_lv_nmos L=8u W=0.15u AS=0.1005p AD=0.0555p
+ PS=1.34u PD=0.74u rfmode=0
M$127 vbp code[7] VGND VGND sg13_lv_nmos L=8u W=0.15u AS=0.0555p AD=0.0555p
+ PS=0.74u PD=0.74u rfmode=0
M$128 VGND code[7] vbp VGND sg13_lv_nmos L=8u W=0.15u AS=0.0555p AD=0.0555p
+ PS=0.74u PD=0.74u rfmode=0
M$129 vbp code[7] VGND VGND sg13_lv_nmos L=8u W=0.15u AS=0.0555p AD=0.1005p
+ PS=0.74u PD=1.34u rfmode=0
M$130 VGND code[7] vbp VGND sg13_lv_nmos L=8u W=0.15u AS=0.1005p AD=0.0555p
+ PS=1.34u PD=0.74u rfmode=0
M$131 vbp code[7] VGND VGND sg13_lv_nmos L=8u W=0.15u AS=0.0555p AD=0.0555p
+ PS=0.74u PD=0.74u rfmode=0
M$132 VGND code[7] vbp VGND sg13_lv_nmos L=8u W=0.15u AS=0.0555p AD=0.0555p
+ PS=0.74u PD=0.74u rfmode=0
M$133 vbp code[7] VGND VGND sg13_lv_nmos L=8u W=0.15u AS=0.0555p AD=0.1005p
+ PS=0.74u PD=1.34u rfmode=0
M$134 VGND code[7] vbp VGND sg13_lv_nmos L=8u W=0.15u AS=0.1005p AD=0.0555p
+ PS=1.34u PD=0.74u rfmode=0
M$135 vbp code[7] VGND VGND sg13_lv_nmos L=8u W=0.15u AS=0.0555p AD=0.0555p
+ PS=0.74u PD=0.74u rfmode=0
M$136 VGND code[7] vbp VGND sg13_lv_nmos L=8u W=0.15u AS=0.0555p AD=0.0555p
+ PS=0.74u PD=0.74u rfmode=0
M$137 vbp code[7] VGND VGND sg13_lv_nmos L=8u W=0.15u AS=0.0555p AD=0.1005p
+ PS=0.74u PD=1.34u rfmode=0
M$138 VGND code[7] vbp VGND sg13_lv_nmos L=8u W=0.15u AS=0.1005p AD=0.0555p
+ PS=1.34u PD=0.74u rfmode=0
M$139 vbp code[7] VGND VGND sg13_lv_nmos L=8u W=0.15u AS=0.0555p AD=0.0555p
+ PS=0.74u PD=0.74u rfmode=0
M$140 VGND code[7] vbp VGND sg13_lv_nmos L=8u W=0.15u AS=0.0555p AD=0.0555p
+ PS=0.74u PD=0.74u rfmode=0
M$141 vbp code[7] VGND VGND sg13_lv_nmos L=8u W=0.15u AS=0.0555p AD=0.1005p
+ PS=0.74u PD=1.34u rfmode=0
M$142 VGND code[7] vbp VGND sg13_lv_nmos L=8u W=0.15u AS=0.1005p AD=0.0555p
+ PS=1.34u PD=0.74u rfmode=0
M$143 vbp code[7] VGND VGND sg13_lv_nmos L=8u W=0.15u AS=0.0555p AD=0.0555p
+ PS=0.74u PD=0.74u rfmode=0
M$144 VGND code[7] vbp VGND sg13_lv_nmos L=8u W=0.15u AS=0.0555p AD=0.0555p
+ PS=0.74u PD=0.74u rfmode=0
M$145 vbp code[7] VGND VGND sg13_lv_nmos L=8u W=0.15u AS=0.0555p AD=0.1005p
+ PS=0.74u PD=1.34u rfmode=0
M$146 VGND code[7] vbp VGND sg13_lv_nmos L=8u W=0.15u AS=0.1005p AD=0.0555p
+ PS=1.34u PD=0.74u rfmode=0
M$147 vbp code[7] VGND VGND sg13_lv_nmos L=8u W=0.15u AS=0.0555p AD=0.0555p
+ PS=0.74u PD=0.74u rfmode=0
M$148 VGND code[7] vbp VGND sg13_lv_nmos L=8u W=0.15u AS=0.0555p AD=0.0555p
+ PS=0.74u PD=0.74u rfmode=0
M$149 vbp code[7] VGND VGND sg13_lv_nmos L=8u W=0.15u AS=0.0555p AD=0.1005p
+ PS=0.74u PD=1.34u rfmode=0
M$150 VGND code[7] vbp VGND sg13_lv_nmos L=8u W=0.15u AS=0.1005p AD=0.0555p
+ PS=1.34u PD=0.74u rfmode=0
M$151 vbp code[7] VGND VGND sg13_lv_nmos L=8u W=0.15u AS=0.0555p AD=0.0555p
+ PS=0.74u PD=0.74u rfmode=0
M$152 VGND code[7] vbp VGND sg13_lv_nmos L=8u W=0.15u AS=0.0555p AD=0.0555p
+ PS=0.74u PD=0.74u rfmode=0
M$153 vbp code[7] VGND VGND sg13_lv_nmos L=8u W=0.15u AS=0.0555p AD=0.1005p
+ PS=0.74u PD=1.34u rfmode=0
M$154 VGND code[7] vbp VGND sg13_lv_nmos L=8u W=0.15u AS=0.1005p AD=0.0555p
+ PS=1.34u PD=0.74u rfmode=0
M$155 vbp code[7] VGND VGND sg13_lv_nmos L=8u W=0.15u AS=0.0555p AD=0.0555p
+ PS=0.74u PD=0.74u rfmode=0
M$156 VGND code[7] vbp VGND sg13_lv_nmos L=8u W=0.15u AS=0.0555p AD=0.0555p
+ PS=0.74u PD=0.74u rfmode=0
M$157 vbp code[7] VGND VGND sg13_lv_nmos L=8u W=0.15u AS=0.0555p AD=0.1005p
+ PS=0.74u PD=1.34u rfmode=0
M$158 VGND code[2] vbp VGND sg13_lv_nmos L=8u W=0.15u AS=0.1005p AD=0.0555p
+ PS=1.34u PD=0.74u rfmode=0
M$159 vbp code[2] VGND VGND sg13_lv_nmos L=8u W=0.15u AS=0.0555p AD=0.0555p
+ PS=0.74u PD=0.74u rfmode=0
M$160 VGND code[2] vbp VGND sg13_lv_nmos L=8u W=0.15u AS=0.0555p AD=0.0555p
+ PS=0.74u PD=0.74u rfmode=0
M$161 vbp code[2] VGND VGND sg13_lv_nmos L=8u W=0.15u AS=0.0555p AD=0.1005p
+ PS=0.74u PD=1.34u rfmode=0
M$162 VGND code[7] vbp VGND sg13_lv_nmos L=8u W=0.15u AS=0.1005p AD=0.0555p
+ PS=1.34u PD=0.74u rfmode=0
M$163 vbp code[7] VGND VGND sg13_lv_nmos L=8u W=0.15u AS=0.0555p AD=0.0555p
+ PS=0.74u PD=0.74u rfmode=0
M$164 VGND code[7] vbp VGND sg13_lv_nmos L=8u W=0.15u AS=0.0555p AD=0.0555p
+ PS=0.74u PD=0.74u rfmode=0
M$165 vbp code[7] VGND VGND sg13_lv_nmos L=8u W=0.15u AS=0.0555p AD=0.1005p
+ PS=0.74u PD=1.34u rfmode=0
M$166 VGND code[7] vbp VGND sg13_lv_nmos L=8u W=0.15u AS=0.1005p AD=0.0555p
+ PS=1.34u PD=0.74u rfmode=0
M$167 vbp code[7] VGND VGND sg13_lv_nmos L=8u W=0.15u AS=0.0555p AD=0.0555p
+ PS=0.74u PD=0.74u rfmode=0
M$168 VGND code[7] vbp VGND sg13_lv_nmos L=8u W=0.15u AS=0.0555p AD=0.0555p
+ PS=0.74u PD=0.74u rfmode=0
M$169 vbp code[7] VGND VGND sg13_lv_nmos L=8u W=0.15u AS=0.0555p AD=0.1005p
+ PS=0.74u PD=1.34u rfmode=0
M$170 VGND code[7] vbp VGND sg13_lv_nmos L=8u W=0.15u AS=0.1005p AD=0.0555p
+ PS=1.34u PD=0.74u rfmode=0
M$171 vbp code[7] VGND VGND sg13_lv_nmos L=8u W=0.15u AS=0.0555p AD=0.0555p
+ PS=0.74u PD=0.74u rfmode=0
M$172 VGND code[7] vbp VGND sg13_lv_nmos L=8u W=0.15u AS=0.0555p AD=0.0555p
+ PS=0.74u PD=0.74u rfmode=0
M$173 vbp code[7] VGND VGND sg13_lv_nmos L=8u W=0.15u AS=0.0555p AD=0.1005p
+ PS=0.74u PD=1.34u rfmode=0
M$174 VGND code[7] vbp VGND sg13_lv_nmos L=8u W=0.15u AS=0.1005p AD=0.0555p
+ PS=1.34u PD=0.74u rfmode=0
M$175 vbp code[7] VGND VGND sg13_lv_nmos L=8u W=0.15u AS=0.0555p AD=0.0555p
+ PS=0.74u PD=0.74u rfmode=0
M$176 VGND code[7] vbp VGND sg13_lv_nmos L=8u W=0.15u AS=0.0555p AD=0.0555p
+ PS=0.74u PD=0.74u rfmode=0
M$177 vbp code[7] VGND VGND sg13_lv_nmos L=8u W=0.15u AS=0.0555p AD=0.1005p
+ PS=0.74u PD=1.34u rfmode=0
M$178 VGND code[6] vbp VGND sg13_lv_nmos L=8u W=0.15u AS=0.1005p AD=0.0555p
+ PS=1.34u PD=0.74u rfmode=0
M$179 vbp code[6] VGND VGND sg13_lv_nmos L=8u W=0.15u AS=0.0555p AD=0.0555p
+ PS=0.74u PD=0.74u rfmode=0
M$180 VGND code[6] vbp VGND sg13_lv_nmos L=8u W=0.15u AS=0.0555p AD=0.0555p
+ PS=0.74u PD=0.74u rfmode=0
M$181 vbp code[6] VGND VGND sg13_lv_nmos L=8u W=0.15u AS=0.0555p AD=0.1005p
+ PS=0.74u PD=1.34u rfmode=0
M$182 VGND code[6] vbp VGND sg13_lv_nmos L=8u W=0.15u AS=0.1005p AD=0.0555p
+ PS=1.34u PD=0.74u rfmode=0
M$183 vbp code[6] VGND VGND sg13_lv_nmos L=8u W=0.15u AS=0.0555p AD=0.0555p
+ PS=0.74u PD=0.74u rfmode=0
M$184 VGND code[6] vbp VGND sg13_lv_nmos L=8u W=0.15u AS=0.0555p AD=0.0555p
+ PS=0.74u PD=0.74u rfmode=0
M$185 vbp code[6] VGND VGND sg13_lv_nmos L=8u W=0.15u AS=0.0555p AD=0.1005p
+ PS=0.74u PD=1.34u rfmode=0
M$186 VGND code[6] vbp VGND sg13_lv_nmos L=8u W=0.15u AS=0.1005p AD=0.0555p
+ PS=1.34u PD=0.74u rfmode=0
M$187 vbp code[6] VGND VGND sg13_lv_nmos L=8u W=0.15u AS=0.0555p AD=0.0555p
+ PS=0.74u PD=0.74u rfmode=0
M$188 VGND code[6] vbp VGND sg13_lv_nmos L=8u W=0.15u AS=0.0555p AD=0.0555p
+ PS=0.74u PD=0.74u rfmode=0
M$189 vbp code[6] VGND VGND sg13_lv_nmos L=8u W=0.15u AS=0.0555p AD=0.1005p
+ PS=0.74u PD=1.34u rfmode=0
M$190 VGND code[6] vbp VGND sg13_lv_nmos L=8u W=0.15u AS=0.1005p AD=0.0555p
+ PS=1.34u PD=0.74u rfmode=0
M$191 vbp code[6] VGND VGND sg13_lv_nmos L=8u W=0.15u AS=0.0555p AD=0.0555p
+ PS=0.74u PD=0.74u rfmode=0
M$192 VGND code[6] vbp VGND sg13_lv_nmos L=8u W=0.15u AS=0.0555p AD=0.0555p
+ PS=0.74u PD=0.74u rfmode=0
M$193 vbp code[6] VGND VGND sg13_lv_nmos L=8u W=0.15u AS=0.0555p AD=0.1005p
+ PS=0.74u PD=1.34u rfmode=0
M$194 VGND code[6] vbp VGND sg13_lv_nmos L=8u W=0.15u AS=0.1005p AD=0.0555p
+ PS=1.34u PD=0.74u rfmode=0
M$195 vbp code[6] VGND VGND sg13_lv_nmos L=8u W=0.15u AS=0.0555p AD=0.0555p
+ PS=0.74u PD=0.74u rfmode=0
M$196 VGND code[6] vbp VGND sg13_lv_nmos L=8u W=0.15u AS=0.0555p AD=0.0555p
+ PS=0.74u PD=0.74u rfmode=0
M$197 vbp code[6] VGND VGND sg13_lv_nmos L=8u W=0.15u AS=0.0555p AD=0.1005p
+ PS=0.74u PD=1.34u rfmode=0
M$198 VGND code[6] vbp VGND sg13_lv_nmos L=8u W=0.15u AS=0.1005p AD=0.0555p
+ PS=1.34u PD=0.74u rfmode=0
M$199 vbp code[6] VGND VGND sg13_lv_nmos L=8u W=0.15u AS=0.0555p AD=0.0555p
+ PS=0.74u PD=0.74u rfmode=0
M$200 VGND code[6] vbp VGND sg13_lv_nmos L=8u W=0.15u AS=0.0555p AD=0.0555p
+ PS=0.74u PD=0.74u rfmode=0
M$201 vbp code[6] VGND VGND sg13_lv_nmos L=8u W=0.15u AS=0.0555p AD=0.1005p
+ PS=0.74u PD=1.34u rfmode=0
M$202 VGND code[7] vbp VGND sg13_lv_nmos L=8u W=0.15u AS=0.1005p AD=0.0555p
+ PS=1.34u PD=0.74u rfmode=0
M$203 vbp code[7] VGND VGND sg13_lv_nmos L=8u W=0.15u AS=0.0555p AD=0.0555p
+ PS=0.74u PD=0.74u rfmode=0
M$204 VGND code[7] vbp VGND sg13_lv_nmos L=8u W=0.15u AS=0.0555p AD=0.0555p
+ PS=0.74u PD=0.74u rfmode=0
M$205 vbp code[7] VGND VGND sg13_lv_nmos L=8u W=0.15u AS=0.0555p AD=0.1005p
+ PS=0.74u PD=1.34u rfmode=0
M$206 VGND code[7] vbp VGND sg13_lv_nmos L=8u W=0.15u AS=0.1005p AD=0.0555p
+ PS=1.34u PD=0.74u rfmode=0
M$207 vbp code[7] VGND VGND sg13_lv_nmos L=8u W=0.15u AS=0.0555p AD=0.0555p
+ PS=0.74u PD=0.74u rfmode=0
M$208 VGND code[7] vbp VGND sg13_lv_nmos L=8u W=0.15u AS=0.0555p AD=0.0555p
+ PS=0.74u PD=0.74u rfmode=0
M$209 vbp code[7] VGND VGND sg13_lv_nmos L=8u W=0.15u AS=0.0555p AD=0.1005p
+ PS=0.74u PD=1.34u rfmode=0
M$210 VGND code[7] vbp VGND sg13_lv_nmos L=8u W=0.15u AS=0.1005p AD=0.0555p
+ PS=1.34u PD=0.74u rfmode=0
M$211 vbp code[7] VGND VGND sg13_lv_nmos L=8u W=0.15u AS=0.0555p AD=0.0555p
+ PS=0.74u PD=0.74u rfmode=0
M$212 VGND code[7] vbp VGND sg13_lv_nmos L=8u W=0.15u AS=0.0555p AD=0.0555p
+ PS=0.74u PD=0.74u rfmode=0
M$213 vbp code[7] VGND VGND sg13_lv_nmos L=8u W=0.15u AS=0.0555p AD=0.1005p
+ PS=0.74u PD=1.34u rfmode=0
M$214 VGND code[6] vbp VGND sg13_lv_nmos L=8u W=0.15u AS=0.1005p AD=0.0555p
+ PS=1.34u PD=0.74u rfmode=0
M$215 vbp code[6] VGND VGND sg13_lv_nmos L=8u W=0.15u AS=0.0555p AD=0.0555p
+ PS=0.74u PD=0.74u rfmode=0
M$216 VGND code[6] vbp VGND sg13_lv_nmos L=8u W=0.15u AS=0.0555p AD=0.0555p
+ PS=0.74u PD=0.74u rfmode=0
M$217 vbp code[6] VGND VGND sg13_lv_nmos L=8u W=0.15u AS=0.0555p AD=0.1005p
+ PS=0.74u PD=1.34u rfmode=0
M$218 VGND code[7] vbp VGND sg13_lv_nmos L=8u W=0.15u AS=0.1005p AD=0.0555p
+ PS=1.34u PD=0.74u rfmode=0
M$219 vbp code[7] VGND VGND sg13_lv_nmos L=8u W=0.15u AS=0.0555p AD=0.0555p
+ PS=0.74u PD=0.74u rfmode=0
M$220 VGND code[7] vbp VGND sg13_lv_nmos L=8u W=0.15u AS=0.0555p AD=0.0555p
+ PS=0.74u PD=0.74u rfmode=0
M$221 vbp code[7] VGND VGND sg13_lv_nmos L=8u W=0.15u AS=0.0555p AD=0.1005p
+ PS=0.74u PD=1.34u rfmode=0
M$222 VGND code[7] vbp VGND sg13_lv_nmos L=8u W=0.15u AS=0.1005p AD=0.0555p
+ PS=1.34u PD=0.74u rfmode=0
M$223 vbp code[7] VGND VGND sg13_lv_nmos L=8u W=0.15u AS=0.0555p AD=0.0555p
+ PS=0.74u PD=0.74u rfmode=0
M$224 VGND code[7] vbp VGND sg13_lv_nmos L=8u W=0.15u AS=0.0555p AD=0.0555p
+ PS=0.74u PD=0.74u rfmode=0
M$225 vbp code[7] VGND VGND sg13_lv_nmos L=8u W=0.15u AS=0.0555p AD=0.1005p
+ PS=0.74u PD=1.34u rfmode=0
M$226 VGND code[6] vbp VGND sg13_lv_nmos L=8u W=0.15u AS=0.1005p AD=0.0555p
+ PS=1.34u PD=0.74u rfmode=0
M$227 vbp code[6] VGND VGND sg13_lv_nmos L=8u W=0.15u AS=0.0555p AD=0.0555p
+ PS=0.74u PD=0.74u rfmode=0
M$228 VGND code[6] vbp VGND sg13_lv_nmos L=8u W=0.15u AS=0.0555p AD=0.0555p
+ PS=0.74u PD=0.74u rfmode=0
M$229 vbp code[6] VGND VGND sg13_lv_nmos L=8u W=0.15u AS=0.0555p AD=0.1005p
+ PS=0.74u PD=1.34u rfmode=0
M$230 VGND code[7] vbp VGND sg13_lv_nmos L=8u W=0.15u AS=0.1005p AD=0.0555p
+ PS=1.34u PD=0.74u rfmode=0
M$231 vbp code[7] VGND VGND sg13_lv_nmos L=8u W=0.15u AS=0.0555p AD=0.0555p
+ PS=0.74u PD=0.74u rfmode=0
M$232 VGND code[7] vbp VGND sg13_lv_nmos L=8u W=0.15u AS=0.0555p AD=0.0555p
+ PS=0.74u PD=0.74u rfmode=0
M$233 vbp code[7] VGND VGND sg13_lv_nmos L=8u W=0.15u AS=0.0555p AD=0.1005p
+ PS=0.74u PD=1.34u rfmode=0
M$234 VGND code[7] vbp VGND sg13_lv_nmos L=8u W=0.15u AS=0.1005p AD=0.0555p
+ PS=1.34u PD=0.74u rfmode=0
M$235 vbp code[7] VGND VGND sg13_lv_nmos L=8u W=0.15u AS=0.0555p AD=0.0555p
+ PS=0.74u PD=0.74u rfmode=0
M$236 VGND code[7] vbp VGND sg13_lv_nmos L=8u W=0.15u AS=0.0555p AD=0.0555p
+ PS=0.74u PD=0.74u rfmode=0
M$237 vbp code[7] VGND VGND sg13_lv_nmos L=8u W=0.15u AS=0.0555p AD=0.1005p
+ PS=0.74u PD=1.34u rfmode=0
M$238 VGND code[7] vbp VGND sg13_lv_nmos L=8u W=0.15u AS=0.1005p AD=0.0555p
+ PS=1.34u PD=0.74u rfmode=0
M$239 vbp code[7] VGND VGND sg13_lv_nmos L=8u W=0.15u AS=0.0555p AD=0.0555p
+ PS=0.74u PD=0.74u rfmode=0
M$240 VGND code[7] vbp VGND sg13_lv_nmos L=8u W=0.15u AS=0.0555p AD=0.0555p
+ PS=0.74u PD=0.74u rfmode=0
M$241 vbp code[7] VGND VGND sg13_lv_nmos L=8u W=0.15u AS=0.0555p AD=0.1005p
+ PS=0.74u PD=1.34u rfmode=0
M$242 VGND code[6] vbp VGND sg13_lv_nmos L=8u W=0.15u AS=0.1005p AD=0.0555p
+ PS=1.34u PD=0.74u rfmode=0
M$243 vbp code[6] VGND VGND sg13_lv_nmos L=8u W=0.15u AS=0.0555p AD=0.0555p
+ PS=0.74u PD=0.74u rfmode=0
M$244 VGND code[6] vbp VGND sg13_lv_nmos L=8u W=0.15u AS=0.0555p AD=0.0555p
+ PS=0.74u PD=0.74u rfmode=0
M$245 vbp code[6] VGND VGND sg13_lv_nmos L=8u W=0.15u AS=0.0555p AD=0.1005p
+ PS=0.74u PD=1.34u rfmode=0
M$246 VGND code[7] vbp VGND sg13_lv_nmos L=8u W=0.15u AS=0.1005p AD=0.0555p
+ PS=1.34u PD=0.74u rfmode=0
M$247 vbp code[7] VGND VGND sg13_lv_nmos L=8u W=0.15u AS=0.0555p AD=0.0555p
+ PS=0.74u PD=0.74u rfmode=0
M$248 VGND code[7] vbp VGND sg13_lv_nmos L=8u W=0.15u AS=0.0555p AD=0.0555p
+ PS=0.74u PD=0.74u rfmode=0
M$249 vbp code[7] VGND VGND sg13_lv_nmos L=8u W=0.15u AS=0.0555p AD=0.1005p
+ PS=0.74u PD=1.34u rfmode=0
M$250 VGND code[7] vbp VGND sg13_lv_nmos L=8u W=0.15u AS=0.1005p AD=0.0555p
+ PS=1.34u PD=0.74u rfmode=0
M$251 vbp code[7] VGND VGND sg13_lv_nmos L=8u W=0.15u AS=0.0555p AD=0.0555p
+ PS=0.74u PD=0.74u rfmode=0
M$252 VGND code[7] vbp VGND sg13_lv_nmos L=8u W=0.15u AS=0.0555p AD=0.0555p
+ PS=0.74u PD=0.74u rfmode=0
M$253 vbp code[7] VGND VGND sg13_lv_nmos L=8u W=0.15u AS=0.0555p AD=0.1005p
+ PS=0.74u PD=1.34u rfmode=0
M$254 VGND code[6] vbp VGND sg13_lv_nmos L=8u W=0.15u AS=0.1005p AD=0.0555p
+ PS=1.34u PD=0.74u rfmode=0
M$255 vbp code[6] VGND VGND sg13_lv_nmos L=8u W=0.15u AS=0.0555p AD=0.0555p
+ PS=0.74u PD=0.74u rfmode=0
M$256 VGND code[6] vbp VGND sg13_lv_nmos L=8u W=0.15u AS=0.0555p AD=0.0555p
+ PS=0.74u PD=0.74u rfmode=0
M$257 vbp code[6] VGND VGND sg13_lv_nmos L=8u W=0.15u AS=0.0555p AD=0.1005p
+ PS=0.74u PD=1.34u rfmode=0
M$258 VGND code[7] vbp VGND sg13_lv_nmos L=8u W=0.15u AS=0.1005p AD=0.0555p
+ PS=1.34u PD=0.74u rfmode=0
M$259 vbp code[7] VGND VGND sg13_lv_nmos L=8u W=0.15u AS=0.0555p AD=0.0555p
+ PS=0.74u PD=0.74u rfmode=0
M$260 VGND code[7] vbp VGND sg13_lv_nmos L=8u W=0.15u AS=0.0555p AD=0.0555p
+ PS=0.74u PD=0.74u rfmode=0
M$261 vbp code[7] VGND VGND sg13_lv_nmos L=8u W=0.15u AS=0.0555p AD=0.1005p
+ PS=0.74u PD=1.34u rfmode=0
M$262 VGND code[7] vbp VGND sg13_lv_nmos L=8u W=0.15u AS=0.1005p AD=0.0555p
+ PS=1.34u PD=0.74u rfmode=0
M$263 vbp code[7] VGND VGND sg13_lv_nmos L=8u W=0.15u AS=0.0555p AD=0.0555p
+ PS=0.74u PD=0.74u rfmode=0
M$264 VGND code[7] vbp VGND sg13_lv_nmos L=8u W=0.15u AS=0.0555p AD=0.0555p
+ PS=0.74u PD=0.74u rfmode=0
M$265 vbp code[7] VGND VGND sg13_lv_nmos L=8u W=0.15u AS=0.0555p AD=0.1005p
+ PS=0.74u PD=1.34u rfmode=0
M$266 VGND code[7] vbp VGND sg13_lv_nmos L=8u W=0.15u AS=0.1005p AD=0.0555p
+ PS=1.34u PD=0.74u rfmode=0
M$267 vbp code[7] VGND VGND sg13_lv_nmos L=8u W=0.15u AS=0.0555p AD=0.0555p
+ PS=0.74u PD=0.74u rfmode=0
M$268 VGND code[7] vbp VGND sg13_lv_nmos L=8u W=0.15u AS=0.0555p AD=0.0555p
+ PS=0.74u PD=0.74u rfmode=0
M$269 vbp code[7] VGND VGND sg13_lv_nmos L=8u W=0.15u AS=0.0555p AD=0.1005p
+ PS=0.74u PD=1.34u rfmode=0
M$270 VGND code[7] vbp VGND sg13_lv_nmos L=8u W=0.15u AS=0.1005p AD=0.0555p
+ PS=1.34u PD=0.74u rfmode=0
M$271 vbp code[7] VGND VGND sg13_lv_nmos L=8u W=0.15u AS=0.0555p AD=0.0555p
+ PS=0.74u PD=0.74u rfmode=0
M$272 VGND code[7] vbp VGND sg13_lv_nmos L=8u W=0.15u AS=0.0555p AD=0.0555p
+ PS=0.74u PD=0.74u rfmode=0
M$273 vbp code[7] VGND VGND sg13_lv_nmos L=8u W=0.15u AS=0.0555p AD=0.1005p
+ PS=0.74u PD=1.34u rfmode=0
M$274 VGND code[7] vbp VGND sg13_lv_nmos L=8u W=0.15u AS=0.1005p AD=0.0555p
+ PS=1.34u PD=0.74u rfmode=0
M$275 vbp code[7] VGND VGND sg13_lv_nmos L=8u W=0.15u AS=0.0555p AD=0.0555p
+ PS=0.74u PD=0.74u rfmode=0
M$276 VGND code[7] vbp VGND sg13_lv_nmos L=8u W=0.15u AS=0.0555p AD=0.0555p
+ PS=0.74u PD=0.74u rfmode=0
M$277 vbp code[7] VGND VGND sg13_lv_nmos L=8u W=0.15u AS=0.0555p AD=0.1005p
+ PS=0.74u PD=1.34u rfmode=0
M$278 VGND code[7] vbp VGND sg13_lv_nmos L=8u W=0.15u AS=0.1005p AD=0.0555p
+ PS=1.34u PD=0.74u rfmode=0
M$279 vbp code[7] VGND VGND sg13_lv_nmos L=8u W=0.15u AS=0.0555p AD=0.0555p
+ PS=0.74u PD=0.74u rfmode=0
M$280 VGND code[7] vbp VGND sg13_lv_nmos L=8u W=0.15u AS=0.0555p AD=0.0555p
+ PS=0.74u PD=0.74u rfmode=0
M$281 vbp code[7] VGND VGND sg13_lv_nmos L=8u W=0.15u AS=0.0555p AD=0.1005p
+ PS=0.74u PD=1.34u rfmode=0
M$282 VGND code[7] vbp VGND sg13_lv_nmos L=8u W=0.15u AS=0.1005p AD=0.0555p
+ PS=1.34u PD=0.74u rfmode=0
M$283 vbp code[7] VGND VGND sg13_lv_nmos L=8u W=0.15u AS=0.0555p AD=0.0555p
+ PS=0.74u PD=0.74u rfmode=0
M$284 VGND code[7] vbp VGND sg13_lv_nmos L=8u W=0.15u AS=0.0555p AD=0.0555p
+ PS=0.74u PD=0.74u rfmode=0
M$285 vbp code[7] VGND VGND sg13_lv_nmos L=8u W=0.15u AS=0.0555p AD=0.1005p
+ PS=0.74u PD=1.34u rfmode=0
M$286 VGND code[7] vbp VGND sg13_lv_nmos L=8u W=0.15u AS=0.1005p AD=0.0555p
+ PS=1.34u PD=0.74u rfmode=0
M$287 vbp code[7] VGND VGND sg13_lv_nmos L=8u W=0.15u AS=0.0555p AD=0.0555p
+ PS=0.74u PD=0.74u rfmode=0
M$288 VGND code[7] vbp VGND sg13_lv_nmos L=8u W=0.15u AS=0.0555p AD=0.0555p
+ PS=0.74u PD=0.74u rfmode=0
M$289 vbp code[7] VGND VGND sg13_lv_nmos L=8u W=0.15u AS=0.0555p AD=0.1005p
+ PS=0.74u PD=1.34u rfmode=0
M$290 VGND code[5] vbp VGND sg13_lv_nmos L=8u W=0.15u AS=0.1005p AD=0.0555p
+ PS=1.34u PD=0.74u rfmode=0
M$291 vbp code[5] VGND VGND sg13_lv_nmos L=8u W=0.15u AS=0.0555p AD=0.0555p
+ PS=0.74u PD=0.74u rfmode=0
M$292 VGND code[5] vbp VGND sg13_lv_nmos L=8u W=0.15u AS=0.0555p AD=0.0555p
+ PS=0.74u PD=0.74u rfmode=0
M$293 vbp code[5] VGND VGND sg13_lv_nmos L=8u W=0.15u AS=0.0555p AD=0.1005p
+ PS=0.74u PD=1.34u rfmode=0
M$294 VGND code[6] vbp VGND sg13_lv_nmos L=8u W=0.15u AS=0.1005p AD=0.0555p
+ PS=1.34u PD=0.74u rfmode=0
M$295 vbp code[6] VGND VGND sg13_lv_nmos L=8u W=0.15u AS=0.0555p AD=0.0555p
+ PS=0.74u PD=0.74u rfmode=0
M$296 VGND code[6] vbp VGND sg13_lv_nmos L=8u W=0.15u AS=0.0555p AD=0.0555p
+ PS=0.74u PD=0.74u rfmode=0
M$297 vbp code[6] VGND VGND sg13_lv_nmos L=8u W=0.15u AS=0.0555p AD=0.1005p
+ PS=0.74u PD=1.34u rfmode=0
M$298 VGND code[3] vbp VGND sg13_lv_nmos L=8u W=0.15u AS=0.1005p AD=0.0555p
+ PS=1.34u PD=0.74u rfmode=0
M$299 vbp code[3] VGND VGND sg13_lv_nmos L=8u W=0.15u AS=0.0555p AD=0.0555p
+ PS=0.74u PD=0.74u rfmode=0
M$300 VGND code[3] vbp VGND sg13_lv_nmos L=8u W=0.15u AS=0.0555p AD=0.0555p
+ PS=0.74u PD=0.74u rfmode=0
M$301 vbp code[3] VGND VGND sg13_lv_nmos L=8u W=0.15u AS=0.0555p AD=0.1005p
+ PS=0.74u PD=1.34u rfmode=0
M$302 VGND code[5] vbp VGND sg13_lv_nmos L=8u W=0.15u AS=0.1005p AD=0.0555p
+ PS=1.34u PD=0.74u rfmode=0
M$303 vbp code[5] VGND VGND sg13_lv_nmos L=8u W=0.15u AS=0.0555p AD=0.0555p
+ PS=0.74u PD=0.74u rfmode=0
M$304 VGND code[5] vbp VGND sg13_lv_nmos L=8u W=0.15u AS=0.0555p AD=0.0555p
+ PS=0.74u PD=0.74u rfmode=0
M$305 vbp code[5] VGND VGND sg13_lv_nmos L=8u W=0.15u AS=0.0555p AD=0.1005p
+ PS=0.74u PD=1.34u rfmode=0
M$306 VGND code[4] vbp VGND sg13_lv_nmos L=8u W=0.15u AS=0.1005p AD=0.0555p
+ PS=1.34u PD=0.74u rfmode=0
M$307 vbp code[4] VGND VGND sg13_lv_nmos L=8u W=0.15u AS=0.0555p AD=0.0555p
+ PS=0.74u PD=0.74u rfmode=0
M$308 VGND code[4] vbp VGND sg13_lv_nmos L=8u W=0.15u AS=0.0555p AD=0.0555p
+ PS=0.74u PD=0.74u rfmode=0
M$309 vbp code[4] VGND VGND sg13_lv_nmos L=8u W=0.15u AS=0.0555p AD=0.1005p
+ PS=0.74u PD=1.34u rfmode=0
M$310 VGND code[6] vbp VGND sg13_lv_nmos L=8u W=0.15u AS=0.1005p AD=0.0555p
+ PS=1.34u PD=0.74u rfmode=0
M$311 vbp code[6] VGND VGND sg13_lv_nmos L=8u W=0.15u AS=0.0555p AD=0.0555p
+ PS=0.74u PD=0.74u rfmode=0
M$312 VGND code[6] vbp VGND sg13_lv_nmos L=8u W=0.15u AS=0.0555p AD=0.0555p
+ PS=0.74u PD=0.74u rfmode=0
M$313 vbp code[6] VGND VGND sg13_lv_nmos L=8u W=0.15u AS=0.0555p AD=0.1005p
+ PS=0.74u PD=1.34u rfmode=0
M$314 VGND code[4] vbp VGND sg13_lv_nmos L=8u W=0.15u AS=0.1005p AD=0.0555p
+ PS=1.34u PD=0.74u rfmode=0
M$315 vbp code[4] VGND VGND sg13_lv_nmos L=8u W=0.15u AS=0.0555p AD=0.0555p
+ PS=0.74u PD=0.74u rfmode=0
M$316 VGND code[4] vbp VGND sg13_lv_nmos L=8u W=0.15u AS=0.0555p AD=0.0555p
+ PS=0.74u PD=0.74u rfmode=0
M$317 vbp code[4] VGND VGND sg13_lv_nmos L=8u W=0.15u AS=0.0555p AD=0.1005p
+ PS=0.74u PD=1.34u rfmode=0
M$318 VGND code[5] vbp VGND sg13_lv_nmos L=8u W=0.15u AS=0.1005p AD=0.0555p
+ PS=1.34u PD=0.74u rfmode=0
M$319 vbp code[5] VGND VGND sg13_lv_nmos L=8u W=0.15u AS=0.0555p AD=0.0555p
+ PS=0.74u PD=0.74u rfmode=0
M$320 VGND code[5] vbp VGND sg13_lv_nmos L=8u W=0.15u AS=0.0555p AD=0.0555p
+ PS=0.74u PD=0.74u rfmode=0
M$321 vbp code[5] VGND VGND sg13_lv_nmos L=8u W=0.15u AS=0.0555p AD=0.1005p
+ PS=0.74u PD=1.34u rfmode=0
M$322 VGND code[5] vbp VGND sg13_lv_nmos L=8u W=0.15u AS=0.1005p AD=0.0555p
+ PS=1.34u PD=0.74u rfmode=0
M$323 vbp code[5] VGND VGND sg13_lv_nmos L=8u W=0.15u AS=0.0555p AD=0.0555p
+ PS=0.74u PD=0.74u rfmode=0
M$324 VGND code[5] vbp VGND sg13_lv_nmos L=8u W=0.15u AS=0.0555p AD=0.0555p
+ PS=0.74u PD=0.74u rfmode=0
M$325 vbp code[5] VGND VGND sg13_lv_nmos L=8u W=0.15u AS=0.0555p AD=0.1005p
+ PS=0.74u PD=1.34u rfmode=0
M$326 VGND code[6] vbp VGND sg13_lv_nmos L=8u W=0.15u AS=0.1005p AD=0.0555p
+ PS=1.34u PD=0.74u rfmode=0
M$327 vbp code[6] VGND VGND sg13_lv_nmos L=8u W=0.15u AS=0.0555p AD=0.0555p
+ PS=0.74u PD=0.74u rfmode=0
M$328 VGND code[6] vbp VGND sg13_lv_nmos L=8u W=0.15u AS=0.0555p AD=0.0555p
+ PS=0.74u PD=0.74u rfmode=0
M$329 vbp code[6] VGND VGND sg13_lv_nmos L=8u W=0.15u AS=0.0555p AD=0.1005p
+ PS=0.74u PD=1.34u rfmode=0
M$330 VGND code[6] vbp VGND sg13_lv_nmos L=8u W=0.15u AS=0.1005p AD=0.0555p
+ PS=1.34u PD=0.74u rfmode=0
M$331 vbp code[6] VGND VGND sg13_lv_nmos L=8u W=0.15u AS=0.0555p AD=0.0555p
+ PS=0.74u PD=0.74u rfmode=0
M$332 VGND code[6] vbp VGND sg13_lv_nmos L=8u W=0.15u AS=0.0555p AD=0.0555p
+ PS=0.74u PD=0.74u rfmode=0
M$333 vbp code[6] VGND VGND sg13_lv_nmos L=8u W=0.15u AS=0.0555p AD=0.1005p
+ PS=0.74u PD=1.34u rfmode=0
.ENDS tt_analog_ring
