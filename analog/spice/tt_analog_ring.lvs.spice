* tt_analog_ring: current-starved ring oscillator + 8-bit binary current DAC
* GENERATED by analog/layout/build_tt_analog_ring.py - do not edit.
* One line per transistor finger, as placed in the layout.
* LVS form: device lines, for KLayout.
.subckt tt_analog_ring code[0] code[1] code[2] code[3] code[4] code[5] code[6] code[7] enable clk_out VPWR VGND
MD7r0h0_0 vbp code[7] VGND VGND sg13_lv_nmos w=0.15u l=8u
MD7r0h0_1 VGND code[7] vbp VGND sg13_lv_nmos w=0.15u l=8u
MD7r0h0_2 vbp code[7] VGND VGND sg13_lv_nmos w=0.15u l=8u
MD7r0h0_3 VGND code[7] vbp VGND sg13_lv_nmos w=0.15u l=8u
MD7r0h1_0 vbp code[7] VGND VGND sg13_lv_nmos w=0.15u l=8u
MD7r0h1_1 VGND code[7] vbp VGND sg13_lv_nmos w=0.15u l=8u
MD7r0h1_2 vbp code[7] VGND VGND sg13_lv_nmos w=0.15u l=8u
MD7r0h1_3 VGND code[7] vbp VGND sg13_lv_nmos w=0.15u l=8u
MD7r1h0_0 vbp code[7] VGND VGND sg13_lv_nmos w=0.15u l=8u
MD7r1h0_1 VGND code[7] vbp VGND sg13_lv_nmos w=0.15u l=8u
MD7r1h0_2 vbp code[7] VGND VGND sg13_lv_nmos w=0.15u l=8u
MD7r1h0_3 VGND code[7] vbp VGND sg13_lv_nmos w=0.15u l=8u
MD7r1h1_0 vbp code[7] VGND VGND sg13_lv_nmos w=0.15u l=8u
MD7r1h1_1 VGND code[7] vbp VGND sg13_lv_nmos w=0.15u l=8u
MD7r1h1_2 vbp code[7] VGND VGND sg13_lv_nmos w=0.15u l=8u
MD7r1h1_3 VGND code[7] vbp VGND sg13_lv_nmos w=0.15u l=8u
MD7r2h0_0 vbp code[7] VGND VGND sg13_lv_nmos w=0.15u l=8u
MD7r2h0_1 VGND code[7] vbp VGND sg13_lv_nmos w=0.15u l=8u
MD7r2h0_2 vbp code[7] VGND VGND sg13_lv_nmos w=0.15u l=8u
MD7r2h0_3 VGND code[7] vbp VGND sg13_lv_nmos w=0.15u l=8u
MD7r2h1_0 vbp code[7] VGND VGND sg13_lv_nmos w=0.15u l=8u
MD7r2h1_1 VGND code[7] vbp VGND sg13_lv_nmos w=0.15u l=8u
MD7r2h1_2 vbp code[7] VGND VGND sg13_lv_nmos w=0.15u l=8u
MD7r2h1_3 VGND code[7] vbp VGND sg13_lv_nmos w=0.15u l=8u
MD7r3h0_0 vbp code[7] VGND VGND sg13_lv_nmos w=0.15u l=8u
MD7r3h0_1 VGND code[7] vbp VGND sg13_lv_nmos w=0.15u l=8u
MD7r3h0_2 vbp code[7] VGND VGND sg13_lv_nmos w=0.15u l=8u
MD7r3h0_3 VGND code[7] vbp VGND sg13_lv_nmos w=0.15u l=8u
MD7r3h1_0 vbp code[7] VGND VGND sg13_lv_nmos w=0.15u l=8u
MD7r3h1_1 VGND code[7] vbp VGND sg13_lv_nmos w=0.15u l=8u
MD7r3h1_2 vbp code[7] VGND VGND sg13_lv_nmos w=0.15u l=8u
MD7r3h1_3 VGND code[7] vbp VGND sg13_lv_nmos w=0.15u l=8u
MD7r4h0_0 vbp code[7] VGND VGND sg13_lv_nmos w=0.15u l=8u
MD7r4h0_1 VGND code[7] vbp VGND sg13_lv_nmos w=0.15u l=8u
MD7r4h0_2 vbp code[7] VGND VGND sg13_lv_nmos w=0.15u l=8u
MD7r4h0_3 VGND code[7] vbp VGND sg13_lv_nmos w=0.15u l=8u
MD7r4h1_0 vbp code[7] VGND VGND sg13_lv_nmos w=0.15u l=8u
MD7r4h1_1 VGND code[7] vbp VGND sg13_lv_nmos w=0.15u l=8u
MD7r4h1_2 vbp code[7] VGND VGND sg13_lv_nmos w=0.15u l=8u
MD7r4h1_3 VGND code[7] vbp VGND sg13_lv_nmos w=0.15u l=8u
MD7r5h0_0 vbp code[7] VGND VGND sg13_lv_nmos w=0.15u l=8u
MD7r5h0_1 VGND code[7] vbp VGND sg13_lv_nmos w=0.15u l=8u
MD7r5h0_2 vbp code[7] VGND VGND sg13_lv_nmos w=0.15u l=8u
MD7r5h0_3 VGND code[7] vbp VGND sg13_lv_nmos w=0.15u l=8u
MD7r5h1_0 vbp code[7] VGND VGND sg13_lv_nmos w=0.15u l=8u
MD7r5h1_1 VGND code[7] vbp VGND sg13_lv_nmos w=0.15u l=8u
MD7r5h1_2 vbp code[7] VGND VGND sg13_lv_nmos w=0.15u l=8u
MD7r5h1_3 VGND code[7] vbp VGND sg13_lv_nmos w=0.15u l=8u
MD7r6h0_0 vbp code[7] VGND VGND sg13_lv_nmos w=0.15u l=8u
MD7r6h0_1 VGND code[7] vbp VGND sg13_lv_nmos w=0.15u l=8u
MD7r6h0_2 vbp code[7] VGND VGND sg13_lv_nmos w=0.15u l=8u
MD7r6h0_3 VGND code[7] vbp VGND sg13_lv_nmos w=0.15u l=8u
MD7r6h1_0 vbp code[7] VGND VGND sg13_lv_nmos w=0.15u l=8u
MD7r6h1_1 VGND code[7] vbp VGND sg13_lv_nmos w=0.15u l=8u
MD7r6h1_2 vbp code[7] VGND VGND sg13_lv_nmos w=0.15u l=8u
MD7r6h1_3 VGND code[7] vbp VGND sg13_lv_nmos w=0.15u l=8u
MD7r7h0_0 vbp code[7] VGND VGND sg13_lv_nmos w=0.15u l=8u
MD7r7h0_1 VGND code[7] vbp VGND sg13_lv_nmos w=0.15u l=8u
MD7r7h0_2 vbp code[7] VGND VGND sg13_lv_nmos w=0.15u l=8u
MD7r7h0_3 VGND code[7] vbp VGND sg13_lv_nmos w=0.15u l=8u
MD7r7h1_0 vbp code[7] VGND VGND sg13_lv_nmos w=0.15u l=8u
MD7r7h1_1 VGND code[7] vbp VGND sg13_lv_nmos w=0.15u l=8u
MD7r7h1_2 vbp code[7] VGND VGND sg13_lv_nmos w=0.15u l=8u
MD7r7h1_3 VGND code[7] vbp VGND sg13_lv_nmos w=0.15u l=8u
MD7r8h0_0 vbp code[7] VGND VGND sg13_lv_nmos w=0.15u l=8u
MD7r8h0_1 VGND code[7] vbp VGND sg13_lv_nmos w=0.15u l=8u
MD7r8h0_2 vbp code[7] VGND VGND sg13_lv_nmos w=0.15u l=8u
MD7r8h0_3 VGND code[7] vbp VGND sg13_lv_nmos w=0.15u l=8u
MD7r8h1_0 vbp code[7] VGND VGND sg13_lv_nmos w=0.15u l=8u
MD7r8h1_1 VGND code[7] vbp VGND sg13_lv_nmos w=0.15u l=8u
MD7r8h1_2 vbp code[7] VGND VGND sg13_lv_nmos w=0.15u l=8u
MD7r8h1_3 VGND code[7] vbp VGND sg13_lv_nmos w=0.15u l=8u
MD7r9h0_0 vbp code[7] VGND VGND sg13_lv_nmos w=0.15u l=8u
MD7r9h0_1 VGND code[7] vbp VGND sg13_lv_nmos w=0.15u l=8u
MD7r9h0_2 vbp code[7] VGND VGND sg13_lv_nmos w=0.15u l=8u
MD7r9h0_3 VGND code[7] vbp VGND sg13_lv_nmos w=0.15u l=8u
MD7r9h1_0 vbp code[7] VGND VGND sg13_lv_nmos w=0.15u l=8u
MD7r9h1_1 VGND code[7] vbp VGND sg13_lv_nmos w=0.15u l=8u
MD7r9h1_2 vbp code[7] VGND VGND sg13_lv_nmos w=0.15u l=8u
MD7r9h1_3 VGND code[7] vbp VGND sg13_lv_nmos w=0.15u l=8u
MD7r10h0_0 vbp code[7] VGND VGND sg13_lv_nmos w=0.15u l=8u
MD7r10h0_1 VGND code[7] vbp VGND sg13_lv_nmos w=0.15u l=8u
MD7r10h0_2 vbp code[7] VGND VGND sg13_lv_nmos w=0.15u l=8u
MD7r10h0_3 VGND code[7] vbp VGND sg13_lv_nmos w=0.15u l=8u
MD7r10h1_0 vbp code[7] VGND VGND sg13_lv_nmos w=0.15u l=8u
MD7r10h1_1 VGND code[7] vbp VGND sg13_lv_nmos w=0.15u l=8u
MD7r10h1_2 vbp code[7] VGND VGND sg13_lv_nmos w=0.15u l=8u
MD7r10h1_3 VGND code[7] vbp VGND sg13_lv_nmos w=0.15u l=8u
MD7r11h0_0 vbp code[7] VGND VGND sg13_lv_nmos w=0.15u l=8u
MD7r11h0_1 VGND code[7] vbp VGND sg13_lv_nmos w=0.15u l=8u
MD7r11h0_2 vbp code[7] VGND VGND sg13_lv_nmos w=0.15u l=8u
MD7r11h0_3 VGND code[7] vbp VGND sg13_lv_nmos w=0.15u l=8u
MD7r11h1_0 vbp code[7] VGND VGND sg13_lv_nmos w=0.15u l=8u
MD7r11h1_1 VGND code[7] vbp VGND sg13_lv_nmos w=0.15u l=8u
MD7r11h1_2 vbp code[7] VGND VGND sg13_lv_nmos w=0.15u l=8u
MD7r11h1_3 VGND code[7] vbp VGND sg13_lv_nmos w=0.15u l=8u
MD7r12h0_0 vbp code[7] VGND VGND sg13_lv_nmos w=0.15u l=8u
MD7r12h0_1 VGND code[7] vbp VGND sg13_lv_nmos w=0.15u l=8u
MD7r12h0_2 vbp code[7] VGND VGND sg13_lv_nmos w=0.15u l=8u
MD7r12h0_3 VGND code[7] vbp VGND sg13_lv_nmos w=0.15u l=8u
MD7r12h1_0 vbp code[7] VGND VGND sg13_lv_nmos w=0.15u l=8u
MD7r12h1_1 VGND code[7] vbp VGND sg13_lv_nmos w=0.15u l=8u
MD7r12h1_2 vbp code[7] VGND VGND sg13_lv_nmos w=0.15u l=8u
MD7r12h1_3 VGND code[7] vbp VGND sg13_lv_nmos w=0.15u l=8u
MD7r13h0_0 vbp code[7] VGND VGND sg13_lv_nmos w=0.15u l=8u
MD7r13h0_1 VGND code[7] vbp VGND sg13_lv_nmos w=0.15u l=8u
MD7r13h0_2 vbp code[7] VGND VGND sg13_lv_nmos w=0.15u l=8u
MD7r13h0_3 VGND code[7] vbp VGND sg13_lv_nmos w=0.15u l=8u
MD7r13h1_0 vbp code[7] VGND VGND sg13_lv_nmos w=0.15u l=8u
MD7r13h1_1 VGND code[7] vbp VGND sg13_lv_nmos w=0.15u l=8u
MD7r13h1_2 vbp code[7] VGND VGND sg13_lv_nmos w=0.15u l=8u
MD7r13h1_3 VGND code[7] vbp VGND sg13_lv_nmos w=0.15u l=8u
MD7r14h0_0 vbp code[7] VGND VGND sg13_lv_nmos w=0.15u l=8u
MD7r14h0_1 VGND code[7] vbp VGND sg13_lv_nmos w=0.15u l=8u
MD7r14h0_2 vbp code[7] VGND VGND sg13_lv_nmos w=0.15u l=8u
MD7r14h0_3 VGND code[7] vbp VGND sg13_lv_nmos w=0.15u l=8u
MD7r14h1_0 vbp code[7] VGND VGND sg13_lv_nmos w=0.15u l=8u
MD7r14h1_1 VGND code[7] vbp VGND sg13_lv_nmos w=0.15u l=8u
MD7r14h1_2 vbp code[7] VGND VGND sg13_lv_nmos w=0.15u l=8u
MD7r14h1_3 VGND code[7] vbp VGND sg13_lv_nmos w=0.15u l=8u
MD7r15h0_0 vbp code[7] VGND VGND sg13_lv_nmos w=0.15u l=8u
MD7r15h0_1 VGND code[7] vbp VGND sg13_lv_nmos w=0.15u l=8u
MD7r15h0_2 vbp code[7] VGND VGND sg13_lv_nmos w=0.15u l=8u
MD7r15h0_3 VGND code[7] vbp VGND sg13_lv_nmos w=0.15u l=8u
MD7r15h1_0 vbp code[7] VGND VGND sg13_lv_nmos w=0.15u l=8u
MD7r15h1_1 VGND code[7] vbp VGND sg13_lv_nmos w=0.15u l=8u
MD7r15h1_2 vbp code[7] VGND VGND sg13_lv_nmos w=0.15u l=8u
MD7r15h1_3 VGND code[7] vbp VGND sg13_lv_nmos w=0.15u l=8u
MD6r16h0_0 vbp code[6] VGND VGND sg13_lv_nmos w=0.15u l=8u
MD6r16h0_1 VGND code[6] vbp VGND sg13_lv_nmos w=0.15u l=8u
MD6r16h0_2 vbp code[6] VGND VGND sg13_lv_nmos w=0.15u l=8u
MD6r16h0_3 VGND code[6] vbp VGND sg13_lv_nmos w=0.15u l=8u
MD6r16h1_0 vbp code[6] VGND VGND sg13_lv_nmos w=0.15u l=8u
MD6r16h1_1 VGND code[6] vbp VGND sg13_lv_nmos w=0.15u l=8u
MD6r16h1_2 vbp code[6] VGND VGND sg13_lv_nmos w=0.15u l=8u
MD6r16h1_3 VGND code[6] vbp VGND sg13_lv_nmos w=0.15u l=8u
MD6r17h0_0 vbp code[6] VGND VGND sg13_lv_nmos w=0.15u l=8u
MD6r17h0_1 VGND code[6] vbp VGND sg13_lv_nmos w=0.15u l=8u
MD6r17h0_2 vbp code[6] VGND VGND sg13_lv_nmos w=0.15u l=8u
MD6r17h0_3 VGND code[6] vbp VGND sg13_lv_nmos w=0.15u l=8u
MD6r17h1_0 vbp code[6] VGND VGND sg13_lv_nmos w=0.15u l=8u
MD6r17h1_1 VGND code[6] vbp VGND sg13_lv_nmos w=0.15u l=8u
MD6r17h1_2 vbp code[6] VGND VGND sg13_lv_nmos w=0.15u l=8u
MD6r17h1_3 VGND code[6] vbp VGND sg13_lv_nmos w=0.15u l=8u
MD6r18h0_0 vbp code[6] VGND VGND sg13_lv_nmos w=0.15u l=8u
MD6r18h0_1 VGND code[6] vbp VGND sg13_lv_nmos w=0.15u l=8u
MD6r18h0_2 vbp code[6] VGND VGND sg13_lv_nmos w=0.15u l=8u
MD6r18h0_3 VGND code[6] vbp VGND sg13_lv_nmos w=0.15u l=8u
MD6r18h1_0 vbp code[6] VGND VGND sg13_lv_nmos w=0.15u l=8u
MD6r18h1_1 VGND code[6] vbp VGND sg13_lv_nmos w=0.15u l=8u
MD6r18h1_2 vbp code[6] VGND VGND sg13_lv_nmos w=0.15u l=8u
MD6r18h1_3 VGND code[6] vbp VGND sg13_lv_nmos w=0.15u l=8u
MD6r19h0_0 vbp code[6] VGND VGND sg13_lv_nmos w=0.15u l=8u
MD6r19h0_1 VGND code[6] vbp VGND sg13_lv_nmos w=0.15u l=8u
MD6r19h0_2 vbp code[6] VGND VGND sg13_lv_nmos w=0.15u l=8u
MD6r19h0_3 VGND code[6] vbp VGND sg13_lv_nmos w=0.15u l=8u
MD6r19h1_0 vbp code[6] VGND VGND sg13_lv_nmos w=0.15u l=8u
MD6r19h1_1 VGND code[6] vbp VGND sg13_lv_nmos w=0.15u l=8u
MD6r19h1_2 vbp code[6] VGND VGND sg13_lv_nmos w=0.15u l=8u
MD6r19h1_3 VGND code[6] vbp VGND sg13_lv_nmos w=0.15u l=8u
MD6r20h0_0 vbp code[6] VGND VGND sg13_lv_nmos w=0.15u l=8u
MD6r20h0_1 VGND code[6] vbp VGND sg13_lv_nmos w=0.15u l=8u
MD6r20h0_2 vbp code[6] VGND VGND sg13_lv_nmos w=0.15u l=8u
MD6r20h0_3 VGND code[6] vbp VGND sg13_lv_nmos w=0.15u l=8u
MD6r20h1_0 vbp code[6] VGND VGND sg13_lv_nmos w=0.15u l=8u
MD6r20h1_1 VGND code[6] vbp VGND sg13_lv_nmos w=0.15u l=8u
MD6r20h1_2 vbp code[6] VGND VGND sg13_lv_nmos w=0.15u l=8u
MD6r20h1_3 VGND code[6] vbp VGND sg13_lv_nmos w=0.15u l=8u
MD6r21h0_0 vbp code[6] VGND VGND sg13_lv_nmos w=0.15u l=8u
MD6r21h0_1 VGND code[6] vbp VGND sg13_lv_nmos w=0.15u l=8u
MD6r21h0_2 vbp code[6] VGND VGND sg13_lv_nmos w=0.15u l=8u
MD6r21h0_3 VGND code[6] vbp VGND sg13_lv_nmos w=0.15u l=8u
MD6r21h1_0 vbp code[6] VGND VGND sg13_lv_nmos w=0.15u l=8u
MD6r21h1_1 VGND code[6] vbp VGND sg13_lv_nmos w=0.15u l=8u
MD6r21h1_2 vbp code[6] VGND VGND sg13_lv_nmos w=0.15u l=8u
MD6r21h1_3 VGND code[6] vbp VGND sg13_lv_nmos w=0.15u l=8u
MD6r22h0_0 vbp code[6] VGND VGND sg13_lv_nmos w=0.15u l=8u
MD6r22h0_1 VGND code[6] vbp VGND sg13_lv_nmos w=0.15u l=8u
MD6r22h0_2 vbp code[6] VGND VGND sg13_lv_nmos w=0.15u l=8u
MD6r22h0_3 VGND code[6] vbp VGND sg13_lv_nmos w=0.15u l=8u
MD6r22h1_0 vbp code[6] VGND VGND sg13_lv_nmos w=0.15u l=8u
MD6r22h1_1 VGND code[6] vbp VGND sg13_lv_nmos w=0.15u l=8u
MD6r22h1_2 vbp code[6] VGND VGND sg13_lv_nmos w=0.15u l=8u
MD6r22h1_3 VGND code[6] vbp VGND sg13_lv_nmos w=0.15u l=8u
MD6r23h0_0 vbp code[6] VGND VGND sg13_lv_nmos w=0.15u l=8u
MD6r23h0_1 VGND code[6] vbp VGND sg13_lv_nmos w=0.15u l=8u
MD6r23h0_2 vbp code[6] VGND VGND sg13_lv_nmos w=0.15u l=8u
MD6r23h0_3 VGND code[6] vbp VGND sg13_lv_nmos w=0.15u l=8u
MD6r23h1_0 vbp code[6] VGND VGND sg13_lv_nmos w=0.15u l=8u
MD6r23h1_1 VGND code[6] vbp VGND sg13_lv_nmos w=0.15u l=8u
MD6r23h1_2 vbp code[6] VGND VGND sg13_lv_nmos w=0.15u l=8u
MD6r23h1_3 VGND code[6] vbp VGND sg13_lv_nmos w=0.15u l=8u
MD5r24h0_0 vbp code[5] VGND VGND sg13_lv_nmos w=0.15u l=8u
MD5r24h0_1 VGND code[5] vbp VGND sg13_lv_nmos w=0.15u l=8u
MD5r24h0_2 vbp code[5] VGND VGND sg13_lv_nmos w=0.15u l=8u
MD5r24h0_3 VGND code[5] vbp VGND sg13_lv_nmos w=0.15u l=8u
MD5r24h1_0 vbp code[5] VGND VGND sg13_lv_nmos w=0.15u l=8u
MD5r24h1_1 VGND code[5] vbp VGND sg13_lv_nmos w=0.15u l=8u
MD5r24h1_2 vbp code[5] VGND VGND sg13_lv_nmos w=0.15u l=8u
MD5r24h1_3 VGND code[5] vbp VGND sg13_lv_nmos w=0.15u l=8u
MD5r25h0_0 vbp code[5] VGND VGND sg13_lv_nmos w=0.15u l=8u
MD5r25h0_1 VGND code[5] vbp VGND sg13_lv_nmos w=0.15u l=8u
MD5r25h0_2 vbp code[5] VGND VGND sg13_lv_nmos w=0.15u l=8u
MD5r25h0_3 VGND code[5] vbp VGND sg13_lv_nmos w=0.15u l=8u
MD5r25h1_0 vbp code[5] VGND VGND sg13_lv_nmos w=0.15u l=8u
MD5r25h1_1 VGND code[5] vbp VGND sg13_lv_nmos w=0.15u l=8u
MD5r25h1_2 vbp code[5] VGND VGND sg13_lv_nmos w=0.15u l=8u
MD5r25h1_3 VGND code[5] vbp VGND sg13_lv_nmos w=0.15u l=8u
MD5r26h0_0 vbp code[5] VGND VGND sg13_lv_nmos w=0.15u l=8u
MD5r26h0_1 VGND code[5] vbp VGND sg13_lv_nmos w=0.15u l=8u
MD5r26h0_2 vbp code[5] VGND VGND sg13_lv_nmos w=0.15u l=8u
MD5r26h0_3 VGND code[5] vbp VGND sg13_lv_nmos w=0.15u l=8u
MD5r26h1_0 vbp code[5] VGND VGND sg13_lv_nmos w=0.15u l=8u
MD5r26h1_1 VGND code[5] vbp VGND sg13_lv_nmos w=0.15u l=8u
MD5r26h1_2 vbp code[5] VGND VGND sg13_lv_nmos w=0.15u l=8u
MD5r26h1_3 VGND code[5] vbp VGND sg13_lv_nmos w=0.15u l=8u
MD5r27h0_0 vbp code[5] VGND VGND sg13_lv_nmos w=0.15u l=8u
MD5r27h0_1 VGND code[5] vbp VGND sg13_lv_nmos w=0.15u l=8u
MD5r27h0_2 vbp code[5] VGND VGND sg13_lv_nmos w=0.15u l=8u
MD5r27h0_3 VGND code[5] vbp VGND sg13_lv_nmos w=0.15u l=8u
MD5r27h1_0 vbp code[5] VGND VGND sg13_lv_nmos w=0.15u l=8u
MD5r27h1_1 VGND code[5] vbp VGND sg13_lv_nmos w=0.15u l=8u
MD5r27h1_2 vbp code[5] VGND VGND sg13_lv_nmos w=0.15u l=8u
MD5r27h1_3 VGND code[5] vbp VGND sg13_lv_nmos w=0.15u l=8u
MD4r28h0_0 vbp code[4] VGND VGND sg13_lv_nmos w=0.15u l=8u
MD4r28h0_1 VGND code[4] vbp VGND sg13_lv_nmos w=0.15u l=8u
MD4r28h0_2 vbp code[4] VGND VGND sg13_lv_nmos w=0.15u l=8u
MD4r28h0_3 VGND code[4] vbp VGND sg13_lv_nmos w=0.15u l=8u
MD4r28h1_0 vbp code[4] VGND VGND sg13_lv_nmos w=0.15u l=8u
MD4r28h1_1 VGND code[4] vbp VGND sg13_lv_nmos w=0.15u l=8u
MD4r28h1_2 vbp code[4] VGND VGND sg13_lv_nmos w=0.15u l=8u
MD4r28h1_3 VGND code[4] vbp VGND sg13_lv_nmos w=0.15u l=8u
MD4r29h0_0 vbp code[4] VGND VGND sg13_lv_nmos w=0.15u l=8u
MD4r29h0_1 VGND code[4] vbp VGND sg13_lv_nmos w=0.15u l=8u
MD4r29h0_2 vbp code[4] VGND VGND sg13_lv_nmos w=0.15u l=8u
MD4r29h0_3 VGND code[4] vbp VGND sg13_lv_nmos w=0.15u l=8u
MD4r29h1_0 vbp code[4] VGND VGND sg13_lv_nmos w=0.15u l=8u
MD4r29h1_1 VGND code[4] vbp VGND sg13_lv_nmos w=0.15u l=8u
MD4r29h1_2 vbp code[4] VGND VGND sg13_lv_nmos w=0.15u l=8u
MD4r29h1_3 VGND code[4] vbp VGND sg13_lv_nmos w=0.15u l=8u
MD3r30h0_0 vbp code[3] VGND VGND sg13_lv_nmos w=0.15u l=8u
MD3r30h0_1 VGND code[3] vbp VGND sg13_lv_nmos w=0.15u l=8u
MD3r30h0_2 vbp code[3] VGND VGND sg13_lv_nmos w=0.15u l=8u
MD3r30h0_3 VGND code[3] vbp VGND sg13_lv_nmos w=0.15u l=8u
MD3r30h1_0 vbp code[3] VGND VGND sg13_lv_nmos w=0.15u l=8u
MD3r30h1_1 VGND code[3] vbp VGND sg13_lv_nmos w=0.15u l=8u
MD3r30h1_2 vbp code[3] VGND VGND sg13_lv_nmos w=0.15u l=8u
MD3r30h1_3 VGND code[3] vbp VGND sg13_lv_nmos w=0.15u l=8u
MD2r31h0_0 vbp code[2] VGND VGND sg13_lv_nmos w=0.15u l=8u
MD2r31h0_1 VGND code[2] vbp VGND sg13_lv_nmos w=0.15u l=8u
MD2r31h0_2 vbp code[2] VGND VGND sg13_lv_nmos w=0.15u l=8u
MD2r31h0_3 VGND code[2] vbp VGND sg13_lv_nmos w=0.15u l=8u
MD1r32h0_0 vbp code[1] VGND VGND sg13_lv_nmos w=0.15u l=8u
MD1r32h0_1 VGND code[1] vbp VGND sg13_lv_nmos w=0.15u l=8u
MD0r33h0_0 vbp code[0] VGND VGND sg13_lv_nmos w=0.15u l=8u
MDON_0 vbp VPWR VGND VGND sg13_lv_nmos w=0.15u l=8u
MDON_1 VGND VPWR vbp VGND sg13_lv_nmos w=0.15u l=8u
MMPD_0 vbp vbp VPWR VPWR sg13_lv_pmos w=2u l=0.5u
MMPD_1 VPWR vbp vbp VPWR sg13_lv_pmos w=2u l=0.5u
MMPD_2 vbp vbp VPWR VPWR sg13_lv_pmos w=2u l=0.5u
MMPD_3 VPWR vbp vbp VPWR sg13_lv_pmos w=2u l=0.5u
MMPD_4 vbp vbp VPWR VPWR sg13_lv_pmos w=2u l=0.5u
MMPD_5 VPWR vbp vbp VPWR sg13_lv_pmos w=2u l=0.5u
MMPD_6 vbp vbp VPWR VPWR sg13_lv_pmos w=2u l=0.5u
MMPD_7 VPWR vbp vbp VPWR sg13_lv_pmos w=2u l=0.5u
MMPD_8 vbp vbp VPWR VPWR sg13_lv_pmos w=2u l=0.5u
MMPD_9 VPWR vbp vbp VPWR sg13_lv_pmos w=2u l=0.5u
MMPD_10 vbp vbp VPWR VPWR sg13_lv_pmos w=2u l=0.5u
MMPD_11 VPWR vbp vbp VPWR sg13_lv_pmos w=2u l=0.5u
MMPD_12 vbp vbp VPWR VPWR sg13_lv_pmos w=2u l=0.5u
MMPD_13 VPWR vbp vbp VPWR sg13_lv_pmos w=2u l=0.5u
MMPD_14 vbp vbp VPWR VPWR sg13_lv_pmos w=2u l=0.5u
MMPD_15 VPWR vbp vbp VPWR sg13_lv_pmos w=2u l=0.5u
MMPD_16 vbp vbp VPWR VPWR sg13_lv_pmos w=2u l=0.5u
MMPD_17 VPWR vbp vbp VPWR sg13_lv_pmos w=2u l=0.5u
MMPD_18 vbp vbp VPWR VPWR sg13_lv_pmos w=2u l=0.5u
MMPD_19 VPWR vbp vbp VPWR sg13_lv_pmos w=2u l=0.5u
MMPD_20 vbp vbp VPWR VPWR sg13_lv_pmos w=2u l=0.5u
MMPD_21 VPWR vbp vbp VPWR sg13_lv_pmos w=2u l=0.5u
MMPD_22 vbp vbp VPWR VPWR sg13_lv_pmos w=2u l=0.5u
MMPD_23 VPWR vbp vbp VPWR sg13_lv_pmos w=2u l=0.5u
MMND_0 vbn vbn VGND VGND sg13_lv_nmos w=0.5u l=0.5u
MMPM_0 vbn vbp VPWR VPWR sg13_lv_pmos w=1u l=0.5u
MMNS0_0 n0 vbn VGND VGND sg13_lv_nmos w=0.5u l=0.5u
MMPS0_0 p0 vbp VPWR VPWR sg13_lv_pmos w=1u l=0.5u
MMNA0_0 na0 enable n0 VGND sg13_lv_nmos w=0.6u l=0.13u
MMNA0_1 s0 s10 na0 VGND sg13_lv_nmos w=0.6u l=0.13u
MMPA0_0 s0 enable p0 VPWR sg13_lv_pmos w=0.5u l=0.13u
MMPA0_1 p0 s10 s0 VPWR sg13_lv_pmos w=0.5u l=0.13u
MMNS1_0 n1 vbn VGND VGND sg13_lv_nmos w=0.5u l=0.5u
MMPS1_0 p1 vbp VPWR VPWR sg13_lv_pmos w=1u l=0.5u
MMN1_0 s1 s0 n1 VGND sg13_lv_nmos w=0.3u l=0.13u
MMP1_0 s1 s0 p1 VPWR sg13_lv_pmos w=0.5u l=0.13u
MMNS2_0 n2 vbn VGND VGND sg13_lv_nmos w=0.5u l=0.5u
MMPS2_0 p2 vbp VPWR VPWR sg13_lv_pmos w=1u l=0.5u
MMN2_0 s2 s1 n2 VGND sg13_lv_nmos w=0.3u l=0.13u
MMP2_0 s2 s1 p2 VPWR sg13_lv_pmos w=0.5u l=0.13u
MMNS3_0 n3 vbn VGND VGND sg13_lv_nmos w=0.5u l=0.5u
MMPS3_0 p3 vbp VPWR VPWR sg13_lv_pmos w=1u l=0.5u
MMN3_0 s3 s2 n3 VGND sg13_lv_nmos w=0.3u l=0.13u
MMP3_0 s3 s2 p3 VPWR sg13_lv_pmos w=0.5u l=0.13u
MMNS4_0 n4 vbn VGND VGND sg13_lv_nmos w=0.5u l=0.5u
MMPS4_0 p4 vbp VPWR VPWR sg13_lv_pmos w=1u l=0.5u
MMN4_0 s4 s3 n4 VGND sg13_lv_nmos w=0.3u l=0.13u
MMP4_0 s4 s3 p4 VPWR sg13_lv_pmos w=0.5u l=0.13u
MMNS5_0 n5 vbn VGND VGND sg13_lv_nmos w=0.5u l=0.5u
MMPS5_0 p5 vbp VPWR VPWR sg13_lv_pmos w=1u l=0.5u
MMN5_0 s5 s4 n5 VGND sg13_lv_nmos w=0.3u l=0.13u
MMP5_0 s5 s4 p5 VPWR sg13_lv_pmos w=0.5u l=0.13u
MMNS6_0 n6 vbn VGND VGND sg13_lv_nmos w=0.5u l=0.5u
MMPS6_0 p6 vbp VPWR VPWR sg13_lv_pmos w=1u l=0.5u
MMN6_0 s6 s5 n6 VGND sg13_lv_nmos w=0.3u l=0.13u
MMP6_0 s6 s5 p6 VPWR sg13_lv_pmos w=0.5u l=0.13u
MMNS7_0 n7 vbn VGND VGND sg13_lv_nmos w=0.5u l=0.5u
MMPS7_0 p7 vbp VPWR VPWR sg13_lv_pmos w=1u l=0.5u
MMN7_0 s7 s6 n7 VGND sg13_lv_nmos w=0.3u l=0.13u
MMP7_0 s7 s6 p7 VPWR sg13_lv_pmos w=0.5u l=0.13u
MMNS8_0 n8 vbn VGND VGND sg13_lv_nmos w=0.5u l=0.5u
MMPS8_0 p8 vbp VPWR VPWR sg13_lv_pmos w=1u l=0.5u
MMN8_0 s8 s7 n8 VGND sg13_lv_nmos w=0.3u l=0.13u
MMP8_0 s8 s7 p8 VPWR sg13_lv_pmos w=0.5u l=0.13u
MMNS9_0 n9 vbn VGND VGND sg13_lv_nmos w=0.5u l=0.5u
MMPS9_0 p9 vbp VPWR VPWR sg13_lv_pmos w=1u l=0.5u
MMN9_0 s9 s8 n9 VGND sg13_lv_nmos w=0.3u l=0.13u
MMP9_0 s9 s8 p9 VPWR sg13_lv_pmos w=0.5u l=0.13u
MMNS10_0 n10 vbn VGND VGND sg13_lv_nmos w=0.5u l=0.5u
MMPS10_0 p10 vbp VPWR VPWR sg13_lv_pmos w=1u l=0.5u
MMN10_0 s10 s9 n10 VGND sg13_lv_nmos w=0.3u l=0.13u
MMP10_0 s10 s9 p10 VPWR sg13_lv_pmos w=0.5u l=0.13u
MMB1N_0 b1 s10 VGND VGND sg13_lv_nmos w=0.3u l=0.13u
MMB1P_0 b1 s10 VPWR VPWR sg13_lv_pmos w=0.5u l=0.13u
MMB2N_0 clk_out b1 VGND VGND sg13_lv_nmos w=1u l=0.13u
MMB2P_0 clk_out b1 VPWR VPWR sg13_lv_pmos w=2u l=0.13u
.ends
