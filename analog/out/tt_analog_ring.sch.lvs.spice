* tt_analog_ring, flat netlist from the xschem schematic (make lvs-sch)
.subckt tt_analog_ring code[0] code[1] code[2] code[3] code[4] code[5] code[6] code[7] enable clk_out VPWR VGND
MD0_XDAC VBP CODE[0] VGND VGND SG13_LV_NMOS W=0.15U L=8U NG=1
MD1_XDAC VBP CODE[1] VGND VGND SG13_LV_NMOS W=0.3U L=8U NG=2
MD2_XDAC VBP CODE[2] VGND VGND SG13_LV_NMOS W=0.6U L=8U NG=4
MD3_XDAC VBP CODE[3] VGND VGND SG13_LV_NMOS W=1.2U L=8U NG=8
MD4_XDAC VBP CODE[4] VGND VGND SG13_LV_NMOS W=2.4U L=8U NG=16
MD5_XDAC VBP CODE[5] VGND VGND SG13_LV_NMOS W=4.8U L=8U NG=32
MD6_XDAC VBP CODE[6] VGND VGND SG13_LV_NMOS W=9.6U L=8U NG=64
MD7_XDAC VBP CODE[7] VGND VGND SG13_LV_NMOS W=19.2U L=8U NG=128
MDON_XDAC VBP VPWR VGND VGND SG13_LV_NMOS W=0.3U L=8U NG=2
MMPD VBP VBP VPWR VPWR SG13_LV_PMOS W=48U L=0.5U NG=24
MMPM VBN VBP VPWR VPWR SG13_LV_PMOS W=1U L=0.5U NG=1
MMND VBN VBN VGND VGND SG13_LV_NMOS W=0.5U L=0.5U NG=1
MMPS0_XNAND XNAND_NET1 VBP VPWR VPWR SG13_LV_PMOS W=1U L=0.5U NG=1
MMPA0_XNAND NET1 ENABLE XNAND_NET1 VPWR SG13_LV_PMOS W=0.5U L=0.13U NG=1
MMPB0_XNAND NET1 S10 XNAND_NET1 VPWR SG13_LV_PMOS W=0.5U L=0.13U NG=1
MMNB0_XNAND NET1 S10 XNAND_NET2 VGND SG13_LV_NMOS W=0.6U L=0.13U NG=1
MMNA0_XNAND XNAND_NET2 ENABLE XNAND_NET3 VGND SG13_LV_NMOS W=0.6U L=0.13U NG=1
MMNS0_XNAND XNAND_NET3 VBN VGND VGND SG13_LV_NMOS W=0.5U L=0.5U NG=1
MMPS_X1 X1_NET1 VBP VPWR VPWR SG13_LV_PMOS W=1U L=0.5U NG=1
MMP_X1 NET2 NET1 X1_NET1 VPWR SG13_LV_PMOS W=0.5U L=0.13U NG=1
MMN_X1 NET2 NET1 X1_NET2 VGND SG13_LV_NMOS W=0.3U L=0.13U NG=1
MMNS_X1 X1_NET2 VBN VGND VGND SG13_LV_NMOS W=0.5U L=0.5U NG=1
MMPS_X2 X2_NET1 VBP VPWR VPWR SG13_LV_PMOS W=1U L=0.5U NG=1
MMP_X2 NET3 NET2 X2_NET1 VPWR SG13_LV_PMOS W=0.5U L=0.13U NG=1
MMN_X2 NET3 NET2 X2_NET2 VGND SG13_LV_NMOS W=0.3U L=0.13U NG=1
MMNS_X2 X2_NET2 VBN VGND VGND SG13_LV_NMOS W=0.5U L=0.5U NG=1
MMPS_X3 X3_NET1 VBP VPWR VPWR SG13_LV_PMOS W=1U L=0.5U NG=1
MMP_X3 NET4 NET3 X3_NET1 VPWR SG13_LV_PMOS W=0.5U L=0.13U NG=1
MMN_X3 NET4 NET3 X3_NET2 VGND SG13_LV_NMOS W=0.3U L=0.13U NG=1
MMNS_X3 X3_NET2 VBN VGND VGND SG13_LV_NMOS W=0.5U L=0.5U NG=1
MMPS_X4 X4_NET1 VBP VPWR VPWR SG13_LV_PMOS W=1U L=0.5U NG=1
MMP_X4 NET5 NET4 X4_NET1 VPWR SG13_LV_PMOS W=0.5U L=0.13U NG=1
MMN_X4 NET5 NET4 X4_NET2 VGND SG13_LV_NMOS W=0.3U L=0.13U NG=1
MMNS_X4 X4_NET2 VBN VGND VGND SG13_LV_NMOS W=0.5U L=0.5U NG=1
MMPS_X5 X5_NET1 VBP VPWR VPWR SG13_LV_PMOS W=1U L=0.5U NG=1
MMP_X5 NET6 NET5 X5_NET1 VPWR SG13_LV_PMOS W=0.5U L=0.13U NG=1
MMN_X5 NET6 NET5 X5_NET2 VGND SG13_LV_NMOS W=0.3U L=0.13U NG=1
MMNS_X5 X5_NET2 VBN VGND VGND SG13_LV_NMOS W=0.5U L=0.5U NG=1
MMPS_X6 X6_NET1 VBP VPWR VPWR SG13_LV_PMOS W=1U L=0.5U NG=1
MMP_X6 NET7 NET6 X6_NET1 VPWR SG13_LV_PMOS W=0.5U L=0.13U NG=1
MMN_X6 NET7 NET6 X6_NET2 VGND SG13_LV_NMOS W=0.3U L=0.13U NG=1
MMNS_X6 X6_NET2 VBN VGND VGND SG13_LV_NMOS W=0.5U L=0.5U NG=1
MMPS_X7 X7_NET1 VBP VPWR VPWR SG13_LV_PMOS W=1U L=0.5U NG=1
MMP_X7 NET8 NET7 X7_NET1 VPWR SG13_LV_PMOS W=0.5U L=0.13U NG=1
MMN_X7 NET8 NET7 X7_NET2 VGND SG13_LV_NMOS W=0.3U L=0.13U NG=1
MMNS_X7 X7_NET2 VBN VGND VGND SG13_LV_NMOS W=0.5U L=0.5U NG=1
MMPS_X8 X8_NET1 VBP VPWR VPWR SG13_LV_PMOS W=1U L=0.5U NG=1
MMP_X8 NET9 NET8 X8_NET1 VPWR SG13_LV_PMOS W=0.5U L=0.13U NG=1
MMN_X8 NET9 NET8 X8_NET2 VGND SG13_LV_NMOS W=0.3U L=0.13U NG=1
MMNS_X8 X8_NET2 VBN VGND VGND SG13_LV_NMOS W=0.5U L=0.5U NG=1
MMPS_X9 X9_NET1 VBP VPWR VPWR SG13_LV_PMOS W=1U L=0.5U NG=1
MMP_X9 NET10 NET9 X9_NET1 VPWR SG13_LV_PMOS W=0.5U L=0.13U NG=1
MMN_X9 NET10 NET9 X9_NET2 VGND SG13_LV_NMOS W=0.3U L=0.13U NG=1
MMNS_X9 X9_NET2 VBN VGND VGND SG13_LV_NMOS W=0.5U L=0.5U NG=1
MMPS_X10 X10_NET1 VBP VPWR VPWR SG13_LV_PMOS W=1U L=0.5U NG=1
MMP_X10 S10 NET10 X10_NET1 VPWR SG13_LV_PMOS W=0.5U L=0.13U NG=1
MMN_X10 S10 NET10 X10_NET2 VGND SG13_LV_NMOS W=0.3U L=0.13U NG=1
MMNS_X10 X10_NET2 VBN VGND VGND SG13_LV_NMOS W=0.5U L=0.5U NG=1
MMBP_XB1 NET11 S10 VPWR VPWR SG13_LV_PMOS W=0.5U L=0.13U NG=1
MMBN_XB1 NET11 S10 VGND VGND SG13_LV_NMOS W=0.3U L=0.13U NG=1
MMBP2 CLK_OUT NET11 VPWR VPWR SG13_LV_PMOS W=2U L=0.13U NG=1
MMBN2 CLK_OUT NET11 VGND VGND SG13_LV_NMOS W=1U L=0.13U NG=1
.ends
