* output buffer into 15 fF
.lib /foss/pdks/ihp-sg13g2/libs.tech/ngspice/models/cornerMOSlv.lib mos_ss
.option temp=-40
.include /work/analog/out/blocks/blocks.spice
Vdd VPWR 0 1.08
Vin s10 0 pulse(0 1.08 0.2n 100p 100p 1.406e-09 3.012e-09)
XB1 s10 b1 VPWR 0 csro_inv
XMBP2 clk_out b1 VPWR VPWR sg13_lv_pmos w=2u l=0.13u ng=1
XMBN2 clk_out b1 0 0 sg13_lv_nmos w=1u l=0.13u ng=1
Cload clk_out 0 1.5e-14
.control
tran 2p 1.807e-08
let t4 = 1.205e-08
meas tran vmax max v(clk_out) from=$&t4
meas tran vmin min v(clk_out) from=$&t4
meas tran tr2 when v(clk_out)=0.21600000000000003 rise=4
meas tran tr8 when v(clk_out)=0.8640000000000001 rise=4
meas tran tf8 when v(clk_out)=0.8640000000000001 fall=4
meas tran tf2 when v(clk_out)=0.21600000000000003 fall=4
let trise = tr8 - tr2
let tfall = tf2 - tf8
echo "trise=$&trise tfall=$&tfall"
meas tran tin_r when v(s10)=0.54 rise=4
meas tran tout_r when v(clk_out)=0.54 rise=4
let tpd = tout_r - tin_r
echo "tpd=$&tpd"
.endc
.end
