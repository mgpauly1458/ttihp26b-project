* tt_analog_ring, post-layout: devices + kpex 2.5D parasitic capacitances
* GENERATED by analog/layout/build_sim_post.py from out/pex/tt_analog_ring_pex.spice - do not edit.
* Same ports as spice/tt_analog_ring.spice; internal nets vbp, vbn, s0..s10, b1 keep their names.
.subckt tt_analog_ring code[0] code[1] code[2] code[3] code[4] code[5] code[6] code[7] enable clk_out VPWR VGND
XM1 vbp code[0] VGND VGND sg13_lv_nmos w=0.15u l=8u ng=1 mm_ok=1
XM2 vbp code[1] VGND VGND sg13_lv_nmos w=0.15u l=8u ng=1 mm_ok=1
XM3 VGND code[1] vbp VGND sg13_lv_nmos w=0.15u l=8u ng=1 mm_ok=1
XM4 vbp VPWR VGND VGND sg13_lv_nmos w=0.15u l=8u ng=1 mm_ok=1
XM5 VGND VPWR vbp VGND sg13_lv_nmos w=0.15u l=8u ng=1 mm_ok=1
XM6 clk_out b1 VPWR VPWR sg13_lv_pmos w=2u l=0.13u ng=1 mm_ok=1
XM7 clk_out b1 VGND VGND sg13_lv_nmos w=1u l=0.13u ng=1 mm_ok=1
XM8 s3 s2 n_126 VPWR sg13_lv_pmos w=0.5u l=0.13u ng=1 mm_ok=1
XM9 s2 s1 n_125 VPWR sg13_lv_pmos w=0.5u l=0.13u ng=1 mm_ok=1
XM10 b1 s10 VPWR VPWR sg13_lv_pmos w=0.5u l=0.13u ng=1 mm_ok=1
XM11 s6 s5 n_128 VPWR sg13_lv_pmos w=0.5u l=0.13u ng=1 mm_ok=1
XM12 s10 s9 n_133 VPWR sg13_lv_pmos w=0.5u l=0.13u ng=1 mm_ok=1
XM13 s5 s4 n_129 VPWR sg13_lv_pmos w=0.5u l=0.13u ng=1 mm_ok=1
XM14 s9 s8 n_132 VPWR sg13_lv_pmos w=0.5u l=0.13u ng=1 mm_ok=1
XM15 s7 s6 n_130 VPWR sg13_lv_pmos w=0.5u l=0.13u ng=1 mm_ok=1
XM16 s4 s3 n_127 VPWR sg13_lv_pmos w=0.5u l=0.13u ng=1 mm_ok=1
XM17 s8 s7 n_131 VPWR sg13_lv_pmos w=0.5u l=0.13u ng=1 mm_ok=1
XM18 s1 s0 n_124 VPWR sg13_lv_pmos w=0.5u l=0.13u ng=1 mm_ok=1
XM19 s1 s0 n_71 VGND sg13_lv_nmos w=0.3u l=0.13u ng=1 mm_ok=1
XM20 b1 s10 VGND VGND sg13_lv_nmos w=0.3u l=0.13u ng=1 mm_ok=1
XM21 s7 s6 n_72 VGND sg13_lv_nmos w=0.3u l=0.13u ng=1 mm_ok=1
XM22 s8 s7 n_70 VGND sg13_lv_nmos w=0.3u l=0.13u ng=1 mm_ok=1
XM23 s3 s2 n_77 VGND sg13_lv_nmos w=0.3u l=0.13u ng=1 mm_ok=1
XM24 s2 s1 n_75 VGND sg13_lv_nmos w=0.3u l=0.13u ng=1 mm_ok=1
XM25 s6 s5 n_73 VGND sg13_lv_nmos w=0.3u l=0.13u ng=1 mm_ok=1
XM26 s10 s9 n_67 VGND sg13_lv_nmos w=0.3u l=0.13u ng=1 mm_ok=1
XM27 s4 s3 n_76 VGND sg13_lv_nmos w=0.3u l=0.13u ng=1 mm_ok=1
XM28 s9 s8 n_69 VGND sg13_lv_nmos w=0.3u l=0.13u ng=1 mm_ok=1
XM29 s5 s4 n_74 VGND sg13_lv_nmos w=0.3u l=0.13u ng=1 mm_ok=1
XM30 s0 enable n_122 VPWR sg13_lv_pmos w=0.5u l=0.13u ng=1 mm_ok=1
XM31 n_122 s10 s0 VPWR sg13_lv_pmos w=0.5u l=0.13u ng=1 mm_ok=1
XM32 n_I1005 enable n_68 VGND sg13_lv_nmos w=0.6u l=0.13u ng=1 mm_ok=1
XM33 s0 s10 n_I1005 VGND sg13_lv_nmos w=0.6u l=0.13u ng=1 mm_ok=1
XM34 vbn vbn VGND VGND sg13_lv_nmos w=0.5u l=0.5u ng=1 mm_ok=1
XM35 n_72 vbn VGND VGND sg13_lv_nmos w=0.5u l=0.5u ng=1 mm_ok=1
XM36 n_77 vbn VGND VGND sg13_lv_nmos w=0.5u l=0.5u ng=1 mm_ok=1
XM37 n_68 vbn VGND VGND sg13_lv_nmos w=0.5u l=0.5u ng=1 mm_ok=1
XM38 n_75 vbn VGND VGND sg13_lv_nmos w=0.5u l=0.5u ng=1 mm_ok=1
XM39 n_73 vbn VGND VGND sg13_lv_nmos w=0.5u l=0.5u ng=1 mm_ok=1
XM40 n_69 vbn VGND VGND sg13_lv_nmos w=0.5u l=0.5u ng=1 mm_ok=1
XM41 n_76 vbn VGND VGND sg13_lv_nmos w=0.5u l=0.5u ng=1 mm_ok=1
XM42 n_67 vbn VGND VGND sg13_lv_nmos w=0.5u l=0.5u ng=1 mm_ok=1
XM43 n_71 vbn VGND VGND sg13_lv_nmos w=0.5u l=0.5u ng=1 mm_ok=1
XM44 n_74 vbn VGND VGND sg13_lv_nmos w=0.5u l=0.5u ng=1 mm_ok=1
XM45 n_70 vbn VGND VGND sg13_lv_nmos w=0.5u l=0.5u ng=1 mm_ok=1
XM46 vbn vbp VPWR VPWR sg13_lv_pmos w=1u l=0.5u ng=1 mm_ok=1
XM47 n_130 vbp VPWR VPWR sg13_lv_pmos w=1u l=0.5u ng=1 mm_ok=1
XM48 n_122 vbp VPWR VPWR sg13_lv_pmos w=1u l=0.5u ng=1 mm_ok=1
XM49 n_128 vbp VPWR VPWR sg13_lv_pmos w=1u l=0.5u ng=1 mm_ok=1
XM50 n_125 vbp VPWR VPWR sg13_lv_pmos w=1u l=0.5u ng=1 mm_ok=1
XM51 n_124 vbp VPWR VPWR sg13_lv_pmos w=1u l=0.5u ng=1 mm_ok=1
XM52 n_127 vbp VPWR VPWR sg13_lv_pmos w=1u l=0.5u ng=1 mm_ok=1
XM53 n_126 vbp VPWR VPWR sg13_lv_pmos w=1u l=0.5u ng=1 mm_ok=1
XM54 n_132 vbp VPWR VPWR sg13_lv_pmos w=1u l=0.5u ng=1 mm_ok=1
XM55 n_129 vbp VPWR VPWR sg13_lv_pmos w=1u l=0.5u ng=1 mm_ok=1
XM56 n_133 vbp VPWR VPWR sg13_lv_pmos w=1u l=0.5u ng=1 mm_ok=1
XM57 n_131 vbp VPWR VPWR sg13_lv_pmos w=1u l=0.5u ng=1 mm_ok=1
XM58 vbp vbp VPWR VPWR sg13_lv_pmos w=2u l=0.5u ng=1 mm_ok=1
XM59 VPWR vbp vbp VPWR sg13_lv_pmos w=2u l=0.5u ng=1 mm_ok=1
XM60 vbp vbp VPWR VPWR sg13_lv_pmos w=2u l=0.5u ng=1 mm_ok=1
XM61 VPWR vbp vbp VPWR sg13_lv_pmos w=2u l=0.5u ng=1 mm_ok=1
XM62 vbp vbp VPWR VPWR sg13_lv_pmos w=2u l=0.5u ng=1 mm_ok=1
XM63 VPWR vbp vbp VPWR sg13_lv_pmos w=2u l=0.5u ng=1 mm_ok=1
XM64 vbp vbp VPWR VPWR sg13_lv_pmos w=2u l=0.5u ng=1 mm_ok=1
XM65 VPWR vbp vbp VPWR sg13_lv_pmos w=2u l=0.5u ng=1 mm_ok=1
XM66 vbp vbp VPWR VPWR sg13_lv_pmos w=2u l=0.5u ng=1 mm_ok=1
XM67 VPWR vbp vbp VPWR sg13_lv_pmos w=2u l=0.5u ng=1 mm_ok=1
XM68 vbp vbp VPWR VPWR sg13_lv_pmos w=2u l=0.5u ng=1 mm_ok=1
XM69 VPWR vbp vbp VPWR sg13_lv_pmos w=2u l=0.5u ng=1 mm_ok=1
XM70 vbp vbp VPWR VPWR sg13_lv_pmos w=2u l=0.5u ng=1 mm_ok=1
XM71 VPWR vbp vbp VPWR sg13_lv_pmos w=2u l=0.5u ng=1 mm_ok=1
XM72 vbp vbp VPWR VPWR sg13_lv_pmos w=2u l=0.5u ng=1 mm_ok=1
XM73 VPWR vbp vbp VPWR sg13_lv_pmos w=2u l=0.5u ng=1 mm_ok=1
XM74 vbp vbp VPWR VPWR sg13_lv_pmos w=2u l=0.5u ng=1 mm_ok=1
XM75 VPWR vbp vbp VPWR sg13_lv_pmos w=2u l=0.5u ng=1 mm_ok=1
XM76 vbp vbp VPWR VPWR sg13_lv_pmos w=2u l=0.5u ng=1 mm_ok=1
XM77 VPWR vbp vbp VPWR sg13_lv_pmos w=2u l=0.5u ng=1 mm_ok=1
XM78 vbp vbp VPWR VPWR sg13_lv_pmos w=2u l=0.5u ng=1 mm_ok=1
XM79 VPWR vbp vbp VPWR sg13_lv_pmos w=2u l=0.5u ng=1 mm_ok=1
XM80 vbp vbp VPWR VPWR sg13_lv_pmos w=2u l=0.5u ng=1 mm_ok=1
XM81 VPWR vbp vbp VPWR sg13_lv_pmos w=2u l=0.5u ng=1 mm_ok=1
XM82 vbp code[7] VGND VGND sg13_lv_nmos w=0.15u l=8u ng=1 mm_ok=1
XM83 VGND code[7] vbp VGND sg13_lv_nmos w=0.15u l=8u ng=1 mm_ok=1
XM84 vbp code[7] VGND VGND sg13_lv_nmos w=0.15u l=8u ng=1 mm_ok=1
XM85 VGND code[7] vbp VGND sg13_lv_nmos w=0.15u l=8u ng=1 mm_ok=1
XM86 vbp code[6] VGND VGND sg13_lv_nmos w=0.15u l=8u ng=1 mm_ok=1
XM87 VGND code[6] vbp VGND sg13_lv_nmos w=0.15u l=8u ng=1 mm_ok=1
XM88 vbp code[6] VGND VGND sg13_lv_nmos w=0.15u l=8u ng=1 mm_ok=1
XM89 VGND code[6] vbp VGND sg13_lv_nmos w=0.15u l=8u ng=1 mm_ok=1
XM90 vbp code[5] VGND VGND sg13_lv_nmos w=0.15u l=8u ng=1 mm_ok=1
XM91 VGND code[5] vbp VGND sg13_lv_nmos w=0.15u l=8u ng=1 mm_ok=1
XM92 vbp code[5] VGND VGND sg13_lv_nmos w=0.15u l=8u ng=1 mm_ok=1
XM93 VGND code[5] vbp VGND sg13_lv_nmos w=0.15u l=8u ng=1 mm_ok=1
XM94 vbp code[5] VGND VGND sg13_lv_nmos w=0.15u l=8u ng=1 mm_ok=1
XM95 VGND code[5] vbp VGND sg13_lv_nmos w=0.15u l=8u ng=1 mm_ok=1
XM96 vbp code[5] VGND VGND sg13_lv_nmos w=0.15u l=8u ng=1 mm_ok=1
XM97 VGND code[5] vbp VGND sg13_lv_nmos w=0.15u l=8u ng=1 mm_ok=1
XM98 vbp code[5] VGND VGND sg13_lv_nmos w=0.15u l=8u ng=1 mm_ok=1
XM99 VGND code[5] vbp VGND sg13_lv_nmos w=0.15u l=8u ng=1 mm_ok=1
XM100 vbp code[5] VGND VGND sg13_lv_nmos w=0.15u l=8u ng=1 mm_ok=1
XM101 VGND code[5] vbp VGND sg13_lv_nmos w=0.15u l=8u ng=1 mm_ok=1
XM102 vbp code[5] VGND VGND sg13_lv_nmos w=0.15u l=8u ng=1 mm_ok=1
XM103 VGND code[5] vbp VGND sg13_lv_nmos w=0.15u l=8u ng=1 mm_ok=1
XM104 vbp code[5] VGND VGND sg13_lv_nmos w=0.15u l=8u ng=1 mm_ok=1
XM105 VGND code[5] vbp VGND sg13_lv_nmos w=0.15u l=8u ng=1 mm_ok=1
XM106 vbp code[4] VGND VGND sg13_lv_nmos w=0.15u l=8u ng=1 mm_ok=1
XM107 VGND code[4] vbp VGND sg13_lv_nmos w=0.15u l=8u ng=1 mm_ok=1
XM108 vbp code[4] VGND VGND sg13_lv_nmos w=0.15u l=8u ng=1 mm_ok=1
XM109 VGND code[4] vbp VGND sg13_lv_nmos w=0.15u l=8u ng=1 mm_ok=1
XM110 vbp code[4] VGND VGND sg13_lv_nmos w=0.15u l=8u ng=1 mm_ok=1
XM111 VGND code[4] vbp VGND sg13_lv_nmos w=0.15u l=8u ng=1 mm_ok=1
XM112 vbp code[4] VGND VGND sg13_lv_nmos w=0.15u l=8u ng=1 mm_ok=1
XM113 VGND code[4] vbp VGND sg13_lv_nmos w=0.15u l=8u ng=1 mm_ok=1
XM114 vbp code[3] VGND VGND sg13_lv_nmos w=0.15u l=8u ng=1 mm_ok=1
XM115 VGND code[3] vbp VGND sg13_lv_nmos w=0.15u l=8u ng=1 mm_ok=1
XM116 vbp code[3] VGND VGND sg13_lv_nmos w=0.15u l=8u ng=1 mm_ok=1
XM117 VGND code[3] vbp VGND sg13_lv_nmos w=0.15u l=8u ng=1 mm_ok=1
XM118 vbp code[6] VGND VGND sg13_lv_nmos w=0.15u l=8u ng=1 mm_ok=1
XM119 VGND code[6] vbp VGND sg13_lv_nmos w=0.15u l=8u ng=1 mm_ok=1
XM120 vbp code[6] VGND VGND sg13_lv_nmos w=0.15u l=8u ng=1 mm_ok=1
XM121 VGND code[6] vbp VGND sg13_lv_nmos w=0.15u l=8u ng=1 mm_ok=1
XM122 vbp code[7] VGND VGND sg13_lv_nmos w=0.15u l=8u ng=1 mm_ok=1
XM123 VGND code[7] vbp VGND sg13_lv_nmos w=0.15u l=8u ng=1 mm_ok=1
XM124 vbp code[7] VGND VGND sg13_lv_nmos w=0.15u l=8u ng=1 mm_ok=1
XM125 VGND code[7] vbp VGND sg13_lv_nmos w=0.15u l=8u ng=1 mm_ok=1
XM126 vbp code[7] VGND VGND sg13_lv_nmos w=0.15u l=8u ng=1 mm_ok=1
XM127 VGND code[7] vbp VGND sg13_lv_nmos w=0.15u l=8u ng=1 mm_ok=1
XM128 vbp code[7] VGND VGND sg13_lv_nmos w=0.15u l=8u ng=1 mm_ok=1
XM129 VGND code[7] vbp VGND sg13_lv_nmos w=0.15u l=8u ng=1 mm_ok=1
XM130 vbp code[7] VGND VGND sg13_lv_nmos w=0.15u l=8u ng=1 mm_ok=1
XM131 VGND code[7] vbp VGND sg13_lv_nmos w=0.15u l=8u ng=1 mm_ok=1
XM132 vbp code[7] VGND VGND sg13_lv_nmos w=0.15u l=8u ng=1 mm_ok=1
XM133 VGND code[7] vbp VGND sg13_lv_nmos w=0.15u l=8u ng=1 mm_ok=1
XM134 vbp code[7] VGND VGND sg13_lv_nmos w=0.15u l=8u ng=1 mm_ok=1
XM135 VGND code[7] vbp VGND sg13_lv_nmos w=0.15u l=8u ng=1 mm_ok=1
XM136 vbp code[7] VGND VGND sg13_lv_nmos w=0.15u l=8u ng=1 mm_ok=1
XM137 VGND code[7] vbp VGND sg13_lv_nmos w=0.15u l=8u ng=1 mm_ok=1
XM138 vbp code[7] VGND VGND sg13_lv_nmos w=0.15u l=8u ng=1 mm_ok=1
XM139 VGND code[7] vbp VGND sg13_lv_nmos w=0.15u l=8u ng=1 mm_ok=1
XM140 vbp code[7] VGND VGND sg13_lv_nmos w=0.15u l=8u ng=1 mm_ok=1
XM141 VGND code[7] vbp VGND sg13_lv_nmos w=0.15u l=8u ng=1 mm_ok=1
XM142 vbp code[7] VGND VGND sg13_lv_nmos w=0.15u l=8u ng=1 mm_ok=1
XM143 VGND code[7] vbp VGND sg13_lv_nmos w=0.15u l=8u ng=1 mm_ok=1
XM144 vbp code[7] VGND VGND sg13_lv_nmos w=0.15u l=8u ng=1 mm_ok=1
XM145 VGND code[7] vbp VGND sg13_lv_nmos w=0.15u l=8u ng=1 mm_ok=1
XM146 vbp code[7] VGND VGND sg13_lv_nmos w=0.15u l=8u ng=1 mm_ok=1
XM147 VGND code[7] vbp VGND sg13_lv_nmos w=0.15u l=8u ng=1 mm_ok=1
XM148 vbp code[7] VGND VGND sg13_lv_nmos w=0.15u l=8u ng=1 mm_ok=1
XM149 VGND code[7] vbp VGND sg13_lv_nmos w=0.15u l=8u ng=1 mm_ok=1
XM150 vbp code[7] VGND VGND sg13_lv_nmos w=0.15u l=8u ng=1 mm_ok=1
XM151 VGND code[7] vbp VGND sg13_lv_nmos w=0.15u l=8u ng=1 mm_ok=1
XM152 vbp code[7] VGND VGND sg13_lv_nmos w=0.15u l=8u ng=1 mm_ok=1
XM153 VGND code[7] vbp VGND sg13_lv_nmos w=0.15u l=8u ng=1 mm_ok=1
XM154 vbp code[7] VGND VGND sg13_lv_nmos w=0.15u l=8u ng=1 mm_ok=1
XM155 VGND code[7] vbp VGND sg13_lv_nmos w=0.15u l=8u ng=1 mm_ok=1
XM156 vbp code[7] VGND VGND sg13_lv_nmos w=0.15u l=8u ng=1 mm_ok=1
XM157 VGND code[7] vbp VGND sg13_lv_nmos w=0.15u l=8u ng=1 mm_ok=1
XM158 vbp code[2] VGND VGND sg13_lv_nmos w=0.15u l=8u ng=1 mm_ok=1
XM159 VGND code[2] vbp VGND sg13_lv_nmos w=0.15u l=8u ng=1 mm_ok=1
XM160 vbp code[2] VGND VGND sg13_lv_nmos w=0.15u l=8u ng=1 mm_ok=1
XM161 VGND code[2] vbp VGND sg13_lv_nmos w=0.15u l=8u ng=1 mm_ok=1
XM162 vbp code[7] VGND VGND sg13_lv_nmos w=0.15u l=8u ng=1 mm_ok=1
XM163 VGND code[7] vbp VGND sg13_lv_nmos w=0.15u l=8u ng=1 mm_ok=1
XM164 vbp code[7] VGND VGND sg13_lv_nmos w=0.15u l=8u ng=1 mm_ok=1
XM165 VGND code[7] vbp VGND sg13_lv_nmos w=0.15u l=8u ng=1 mm_ok=1
XM166 vbp code[7] VGND VGND sg13_lv_nmos w=0.15u l=8u ng=1 mm_ok=1
XM167 VGND code[7] vbp VGND sg13_lv_nmos w=0.15u l=8u ng=1 mm_ok=1
XM168 vbp code[7] VGND VGND sg13_lv_nmos w=0.15u l=8u ng=1 mm_ok=1
XM169 VGND code[7] vbp VGND sg13_lv_nmos w=0.15u l=8u ng=1 mm_ok=1
XM170 vbp code[7] VGND VGND sg13_lv_nmos w=0.15u l=8u ng=1 mm_ok=1
XM171 VGND code[7] vbp VGND sg13_lv_nmos w=0.15u l=8u ng=1 mm_ok=1
XM172 vbp code[7] VGND VGND sg13_lv_nmos w=0.15u l=8u ng=1 mm_ok=1
XM173 VGND code[7] vbp VGND sg13_lv_nmos w=0.15u l=8u ng=1 mm_ok=1
XM174 vbp code[7] VGND VGND sg13_lv_nmos w=0.15u l=8u ng=1 mm_ok=1
XM175 VGND code[7] vbp VGND sg13_lv_nmos w=0.15u l=8u ng=1 mm_ok=1
XM176 vbp code[7] VGND VGND sg13_lv_nmos w=0.15u l=8u ng=1 mm_ok=1
XM177 VGND code[7] vbp VGND sg13_lv_nmos w=0.15u l=8u ng=1 mm_ok=1
XM178 vbp code[6] VGND VGND sg13_lv_nmos w=0.15u l=8u ng=1 mm_ok=1
XM179 VGND code[6] vbp VGND sg13_lv_nmos w=0.15u l=8u ng=1 mm_ok=1
XM180 vbp code[6] VGND VGND sg13_lv_nmos w=0.15u l=8u ng=1 mm_ok=1
XM181 VGND code[6] vbp VGND sg13_lv_nmos w=0.15u l=8u ng=1 mm_ok=1
XM182 vbp code[6] VGND VGND sg13_lv_nmos w=0.15u l=8u ng=1 mm_ok=1
XM183 VGND code[6] vbp VGND sg13_lv_nmos w=0.15u l=8u ng=1 mm_ok=1
XM184 vbp code[6] VGND VGND sg13_lv_nmos w=0.15u l=8u ng=1 mm_ok=1
XM185 VGND code[6] vbp VGND sg13_lv_nmos w=0.15u l=8u ng=1 mm_ok=1
XM186 vbp code[6] VGND VGND sg13_lv_nmos w=0.15u l=8u ng=1 mm_ok=1
XM187 VGND code[6] vbp VGND sg13_lv_nmos w=0.15u l=8u ng=1 mm_ok=1
XM188 vbp code[6] VGND VGND sg13_lv_nmos w=0.15u l=8u ng=1 mm_ok=1
XM189 VGND code[6] vbp VGND sg13_lv_nmos w=0.15u l=8u ng=1 mm_ok=1
XM190 vbp code[6] VGND VGND sg13_lv_nmos w=0.15u l=8u ng=1 mm_ok=1
XM191 VGND code[6] vbp VGND sg13_lv_nmos w=0.15u l=8u ng=1 mm_ok=1
XM192 vbp code[6] VGND VGND sg13_lv_nmos w=0.15u l=8u ng=1 mm_ok=1
XM193 VGND code[6] vbp VGND sg13_lv_nmos w=0.15u l=8u ng=1 mm_ok=1
XM194 vbp code[6] VGND VGND sg13_lv_nmos w=0.15u l=8u ng=1 mm_ok=1
XM195 VGND code[6] vbp VGND sg13_lv_nmos w=0.15u l=8u ng=1 mm_ok=1
XM196 vbp code[6] VGND VGND sg13_lv_nmos w=0.15u l=8u ng=1 mm_ok=1
XM197 VGND code[6] vbp VGND sg13_lv_nmos w=0.15u l=8u ng=1 mm_ok=1
XM198 vbp code[6] VGND VGND sg13_lv_nmos w=0.15u l=8u ng=1 mm_ok=1
XM199 VGND code[6] vbp VGND sg13_lv_nmos w=0.15u l=8u ng=1 mm_ok=1
XM200 vbp code[6] VGND VGND sg13_lv_nmos w=0.15u l=8u ng=1 mm_ok=1
XM201 VGND code[6] vbp VGND sg13_lv_nmos w=0.15u l=8u ng=1 mm_ok=1
XM202 vbp code[7] VGND VGND sg13_lv_nmos w=0.15u l=8u ng=1 mm_ok=1
XM203 VGND code[7] vbp VGND sg13_lv_nmos w=0.15u l=8u ng=1 mm_ok=1
XM204 vbp code[7] VGND VGND sg13_lv_nmos w=0.15u l=8u ng=1 mm_ok=1
XM205 VGND code[7] vbp VGND sg13_lv_nmos w=0.15u l=8u ng=1 mm_ok=1
XM206 vbp code[7] VGND VGND sg13_lv_nmos w=0.15u l=8u ng=1 mm_ok=1
XM207 VGND code[7] vbp VGND sg13_lv_nmos w=0.15u l=8u ng=1 mm_ok=1
XM208 vbp code[7] VGND VGND sg13_lv_nmos w=0.15u l=8u ng=1 mm_ok=1
XM209 VGND code[7] vbp VGND sg13_lv_nmos w=0.15u l=8u ng=1 mm_ok=1
XM210 vbp code[7] VGND VGND sg13_lv_nmos w=0.15u l=8u ng=1 mm_ok=1
XM211 VGND code[7] vbp VGND sg13_lv_nmos w=0.15u l=8u ng=1 mm_ok=1
XM212 vbp code[7] VGND VGND sg13_lv_nmos w=0.15u l=8u ng=1 mm_ok=1
XM213 VGND code[7] vbp VGND sg13_lv_nmos w=0.15u l=8u ng=1 mm_ok=1
XM214 vbp code[6] VGND VGND sg13_lv_nmos w=0.15u l=8u ng=1 mm_ok=1
XM215 VGND code[6] vbp VGND sg13_lv_nmos w=0.15u l=8u ng=1 mm_ok=1
XM216 vbp code[6] VGND VGND sg13_lv_nmos w=0.15u l=8u ng=1 mm_ok=1
XM217 VGND code[6] vbp VGND sg13_lv_nmos w=0.15u l=8u ng=1 mm_ok=1
XM218 vbp code[7] VGND VGND sg13_lv_nmos w=0.15u l=8u ng=1 mm_ok=1
XM219 VGND code[7] vbp VGND sg13_lv_nmos w=0.15u l=8u ng=1 mm_ok=1
XM220 vbp code[7] VGND VGND sg13_lv_nmos w=0.15u l=8u ng=1 mm_ok=1
XM221 VGND code[7] vbp VGND sg13_lv_nmos w=0.15u l=8u ng=1 mm_ok=1
XM222 vbp code[7] VGND VGND sg13_lv_nmos w=0.15u l=8u ng=1 mm_ok=1
XM223 VGND code[7] vbp VGND sg13_lv_nmos w=0.15u l=8u ng=1 mm_ok=1
XM224 vbp code[7] VGND VGND sg13_lv_nmos w=0.15u l=8u ng=1 mm_ok=1
XM225 VGND code[7] vbp VGND sg13_lv_nmos w=0.15u l=8u ng=1 mm_ok=1
XM226 vbp code[6] VGND VGND sg13_lv_nmos w=0.15u l=8u ng=1 mm_ok=1
XM227 VGND code[6] vbp VGND sg13_lv_nmos w=0.15u l=8u ng=1 mm_ok=1
XM228 vbp code[6] VGND VGND sg13_lv_nmos w=0.15u l=8u ng=1 mm_ok=1
XM229 VGND code[6] vbp VGND sg13_lv_nmos w=0.15u l=8u ng=1 mm_ok=1
XM230 vbp code[7] VGND VGND sg13_lv_nmos w=0.15u l=8u ng=1 mm_ok=1
XM231 VGND code[7] vbp VGND sg13_lv_nmos w=0.15u l=8u ng=1 mm_ok=1
XM232 vbp code[7] VGND VGND sg13_lv_nmos w=0.15u l=8u ng=1 mm_ok=1
XM233 VGND code[7] vbp VGND sg13_lv_nmos w=0.15u l=8u ng=1 mm_ok=1
XM234 vbp code[7] VGND VGND sg13_lv_nmos w=0.15u l=8u ng=1 mm_ok=1
XM235 VGND code[7] vbp VGND sg13_lv_nmos w=0.15u l=8u ng=1 mm_ok=1
XM236 vbp code[7] VGND VGND sg13_lv_nmos w=0.15u l=8u ng=1 mm_ok=1
XM237 VGND code[7] vbp VGND sg13_lv_nmos w=0.15u l=8u ng=1 mm_ok=1
XM238 vbp code[7] VGND VGND sg13_lv_nmos w=0.15u l=8u ng=1 mm_ok=1
XM239 VGND code[7] vbp VGND sg13_lv_nmos w=0.15u l=8u ng=1 mm_ok=1
XM240 vbp code[7] VGND VGND sg13_lv_nmos w=0.15u l=8u ng=1 mm_ok=1
XM241 VGND code[7] vbp VGND sg13_lv_nmos w=0.15u l=8u ng=1 mm_ok=1
XM242 vbp code[6] VGND VGND sg13_lv_nmos w=0.15u l=8u ng=1 mm_ok=1
XM243 VGND code[6] vbp VGND sg13_lv_nmos w=0.15u l=8u ng=1 mm_ok=1
XM244 vbp code[6] VGND VGND sg13_lv_nmos w=0.15u l=8u ng=1 mm_ok=1
XM245 VGND code[6] vbp VGND sg13_lv_nmos w=0.15u l=8u ng=1 mm_ok=1
XM246 vbp code[7] VGND VGND sg13_lv_nmos w=0.15u l=8u ng=1 mm_ok=1
XM247 VGND code[7] vbp VGND sg13_lv_nmos w=0.15u l=8u ng=1 mm_ok=1
XM248 vbp code[7] VGND VGND sg13_lv_nmos w=0.15u l=8u ng=1 mm_ok=1
XM249 VGND code[7] vbp VGND sg13_lv_nmos w=0.15u l=8u ng=1 mm_ok=1
XM250 vbp code[7] VGND VGND sg13_lv_nmos w=0.15u l=8u ng=1 mm_ok=1
XM251 VGND code[7] vbp VGND sg13_lv_nmos w=0.15u l=8u ng=1 mm_ok=1
XM252 vbp code[7] VGND VGND sg13_lv_nmos w=0.15u l=8u ng=1 mm_ok=1
XM253 VGND code[7] vbp VGND sg13_lv_nmos w=0.15u l=8u ng=1 mm_ok=1
XM254 vbp code[6] VGND VGND sg13_lv_nmos w=0.15u l=8u ng=1 mm_ok=1
XM255 VGND code[6] vbp VGND sg13_lv_nmos w=0.15u l=8u ng=1 mm_ok=1
XM256 vbp code[6] VGND VGND sg13_lv_nmos w=0.15u l=8u ng=1 mm_ok=1
XM257 VGND code[6] vbp VGND sg13_lv_nmos w=0.15u l=8u ng=1 mm_ok=1
XM258 vbp code[7] VGND VGND sg13_lv_nmos w=0.15u l=8u ng=1 mm_ok=1
XM259 VGND code[7] vbp VGND sg13_lv_nmos w=0.15u l=8u ng=1 mm_ok=1
XM260 vbp code[7] VGND VGND sg13_lv_nmos w=0.15u l=8u ng=1 mm_ok=1
XM261 VGND code[7] vbp VGND sg13_lv_nmos w=0.15u l=8u ng=1 mm_ok=1
XM262 vbp code[7] VGND VGND sg13_lv_nmos w=0.15u l=8u ng=1 mm_ok=1
XM263 VGND code[7] vbp VGND sg13_lv_nmos w=0.15u l=8u ng=1 mm_ok=1
XM264 vbp code[7] VGND VGND sg13_lv_nmos w=0.15u l=8u ng=1 mm_ok=1
XM265 VGND code[7] vbp VGND sg13_lv_nmos w=0.15u l=8u ng=1 mm_ok=1
XM266 vbp code[7] VGND VGND sg13_lv_nmos w=0.15u l=8u ng=1 mm_ok=1
XM267 VGND code[7] vbp VGND sg13_lv_nmos w=0.15u l=8u ng=1 mm_ok=1
XM268 vbp code[7] VGND VGND sg13_lv_nmos w=0.15u l=8u ng=1 mm_ok=1
XM269 VGND code[7] vbp VGND sg13_lv_nmos w=0.15u l=8u ng=1 mm_ok=1
XM270 vbp code[7] VGND VGND sg13_lv_nmos w=0.15u l=8u ng=1 mm_ok=1
XM271 VGND code[7] vbp VGND sg13_lv_nmos w=0.15u l=8u ng=1 mm_ok=1
XM272 vbp code[7] VGND VGND sg13_lv_nmos w=0.15u l=8u ng=1 mm_ok=1
XM273 VGND code[7] vbp VGND sg13_lv_nmos w=0.15u l=8u ng=1 mm_ok=1
XM274 vbp code[7] VGND VGND sg13_lv_nmos w=0.15u l=8u ng=1 mm_ok=1
XM275 VGND code[7] vbp VGND sg13_lv_nmos w=0.15u l=8u ng=1 mm_ok=1
XM276 vbp code[7] VGND VGND sg13_lv_nmos w=0.15u l=8u ng=1 mm_ok=1
XM277 VGND code[7] vbp VGND sg13_lv_nmos w=0.15u l=8u ng=1 mm_ok=1
XM278 vbp code[7] VGND VGND sg13_lv_nmos w=0.15u l=8u ng=1 mm_ok=1
XM279 VGND code[7] vbp VGND sg13_lv_nmos w=0.15u l=8u ng=1 mm_ok=1
XM280 vbp code[7] VGND VGND sg13_lv_nmos w=0.15u l=8u ng=1 mm_ok=1
XM281 VGND code[7] vbp VGND sg13_lv_nmos w=0.15u l=8u ng=1 mm_ok=1
XM282 vbp code[7] VGND VGND sg13_lv_nmos w=0.15u l=8u ng=1 mm_ok=1
XM283 VGND code[7] vbp VGND sg13_lv_nmos w=0.15u l=8u ng=1 mm_ok=1
XM284 vbp code[7] VGND VGND sg13_lv_nmos w=0.15u l=8u ng=1 mm_ok=1
XM285 VGND code[7] vbp VGND sg13_lv_nmos w=0.15u l=8u ng=1 mm_ok=1
XM286 vbp code[7] VGND VGND sg13_lv_nmos w=0.15u l=8u ng=1 mm_ok=1
XM287 VGND code[7] vbp VGND sg13_lv_nmos w=0.15u l=8u ng=1 mm_ok=1
XM288 vbp code[7] VGND VGND sg13_lv_nmos w=0.15u l=8u ng=1 mm_ok=1
XM289 VGND code[7] vbp VGND sg13_lv_nmos w=0.15u l=8u ng=1 mm_ok=1
XM290 vbp code[5] VGND VGND sg13_lv_nmos w=0.15u l=8u ng=1 mm_ok=1
XM291 VGND code[5] vbp VGND sg13_lv_nmos w=0.15u l=8u ng=1 mm_ok=1
XM292 vbp code[5] VGND VGND sg13_lv_nmos w=0.15u l=8u ng=1 mm_ok=1
XM293 VGND code[5] vbp VGND sg13_lv_nmos w=0.15u l=8u ng=1 mm_ok=1
XM294 vbp code[6] VGND VGND sg13_lv_nmos w=0.15u l=8u ng=1 mm_ok=1
XM295 VGND code[6] vbp VGND sg13_lv_nmos w=0.15u l=8u ng=1 mm_ok=1
XM296 vbp code[6] VGND VGND sg13_lv_nmos w=0.15u l=8u ng=1 mm_ok=1
XM297 VGND code[6] vbp VGND sg13_lv_nmos w=0.15u l=8u ng=1 mm_ok=1
XM298 vbp code[3] VGND VGND sg13_lv_nmos w=0.15u l=8u ng=1 mm_ok=1
XM299 VGND code[3] vbp VGND sg13_lv_nmos w=0.15u l=8u ng=1 mm_ok=1
XM300 vbp code[3] VGND VGND sg13_lv_nmos w=0.15u l=8u ng=1 mm_ok=1
XM301 VGND code[3] vbp VGND sg13_lv_nmos w=0.15u l=8u ng=1 mm_ok=1
XM302 vbp code[5] VGND VGND sg13_lv_nmos w=0.15u l=8u ng=1 mm_ok=1
XM303 VGND code[5] vbp VGND sg13_lv_nmos w=0.15u l=8u ng=1 mm_ok=1
XM304 vbp code[5] VGND VGND sg13_lv_nmos w=0.15u l=8u ng=1 mm_ok=1
XM305 VGND code[5] vbp VGND sg13_lv_nmos w=0.15u l=8u ng=1 mm_ok=1
XM306 vbp code[4] VGND VGND sg13_lv_nmos w=0.15u l=8u ng=1 mm_ok=1
XM307 VGND code[4] vbp VGND sg13_lv_nmos w=0.15u l=8u ng=1 mm_ok=1
XM308 vbp code[4] VGND VGND sg13_lv_nmos w=0.15u l=8u ng=1 mm_ok=1
XM309 VGND code[4] vbp VGND sg13_lv_nmos w=0.15u l=8u ng=1 mm_ok=1
XM310 vbp code[6] VGND VGND sg13_lv_nmos w=0.15u l=8u ng=1 mm_ok=1
XM311 VGND code[6] vbp VGND sg13_lv_nmos w=0.15u l=8u ng=1 mm_ok=1
XM312 vbp code[6] VGND VGND sg13_lv_nmos w=0.15u l=8u ng=1 mm_ok=1
XM313 VGND code[6] vbp VGND sg13_lv_nmos w=0.15u l=8u ng=1 mm_ok=1
XM314 vbp code[4] VGND VGND sg13_lv_nmos w=0.15u l=8u ng=1 mm_ok=1
XM315 VGND code[4] vbp VGND sg13_lv_nmos w=0.15u l=8u ng=1 mm_ok=1
XM316 vbp code[4] VGND VGND sg13_lv_nmos w=0.15u l=8u ng=1 mm_ok=1
XM317 VGND code[4] vbp VGND sg13_lv_nmos w=0.15u l=8u ng=1 mm_ok=1
XM318 vbp code[5] VGND VGND sg13_lv_nmos w=0.15u l=8u ng=1 mm_ok=1
XM319 VGND code[5] vbp VGND sg13_lv_nmos w=0.15u l=8u ng=1 mm_ok=1
XM320 vbp code[5] VGND VGND sg13_lv_nmos w=0.15u l=8u ng=1 mm_ok=1
XM321 VGND code[5] vbp VGND sg13_lv_nmos w=0.15u l=8u ng=1 mm_ok=1
XM322 vbp code[5] VGND VGND sg13_lv_nmos w=0.15u l=8u ng=1 mm_ok=1
XM323 VGND code[5] vbp VGND sg13_lv_nmos w=0.15u l=8u ng=1 mm_ok=1
XM324 vbp code[5] VGND VGND sg13_lv_nmos w=0.15u l=8u ng=1 mm_ok=1
XM325 VGND code[5] vbp VGND sg13_lv_nmos w=0.15u l=8u ng=1 mm_ok=1
XM326 vbp code[6] VGND VGND sg13_lv_nmos w=0.15u l=8u ng=1 mm_ok=1
XM327 VGND code[6] vbp VGND sg13_lv_nmos w=0.15u l=8u ng=1 mm_ok=1
XM328 vbp code[6] VGND VGND sg13_lv_nmos w=0.15u l=8u ng=1 mm_ok=1
XM329 VGND code[6] vbp VGND sg13_lv_nmos w=0.15u l=8u ng=1 mm_ok=1
XM330 vbp code[6] VGND VGND sg13_lv_nmos w=0.15u l=8u ng=1 mm_ok=1
XM331 VGND code[6] vbp VGND sg13_lv_nmos w=0.15u l=8u ng=1 mm_ok=1
XM332 vbp code[6] VGND VGND sg13_lv_nmos w=0.15u l=8u ng=1 mm_ok=1
XM333 VGND code[6] vbp VGND sg13_lv_nmos w=0.15u l=8u ng=1 mm_ok=1
Cext_1 n_122 n_68 3.55077a
Cext_2 n_122 enable 49.7938a
Cext_3 n_122 s0 121.127a
Cext_4 n_122 s10 21.4871a
Cext_5 n_122 vbn 0.204793a
Cext_6 n_122 vbp 29.8022a
Cext_7 n_122 VGND 2.68005a
Cext_8 n_122 VPWR 166.113a
Cext_9 n_122 VGND 141.491a
Cext_10 n_124 s0 15.1402a
Cext_11 n_124 s1 55.1192a
Cext_12 n_124 s10 4.90318a
Cext_13 n_124 vbn 0.204793a
Cext_14 n_124 vbp 25.7215a
Cext_15 n_124 VGND 0.912863a
Cext_16 n_124 VPWR 70.0244a
Cext_17 n_124 VGND 71.0801a
Cext_18 n_125 s1 15.1402a
Cext_19 n_125 s10 4.90318a
Cext_20 n_125 s2 55.1192a
Cext_21 n_125 vbn 0.204793a
Cext_22 n_125 vbp 25.7215a
Cext_23 n_125 VGND 0.912863a
Cext_24 n_125 VPWR 70.0244a
Cext_25 n_125 VGND 71.0801a
Cext_26 n_126 s10 4.81458a
Cext_27 n_126 s2 15.1402a
Cext_28 n_126 s3 55.1192a
Cext_29 n_126 vbn 0.204793a
Cext_30 n_126 vbp 25.8001a
Cext_31 n_126 VGND 1.13341a
Cext_32 n_126 VPWR 71.3847a
Cext_33 n_126 VGND 71.0801a
Cext_34 n_127 s10 4.90318a
Cext_35 n_127 s3 15.1402a
Cext_36 n_127 s4 55.1192a
Cext_37 n_127 vbn 0.204793a
Cext_38 n_127 vbp 25.8468a
Cext_39 n_127 VGND 0.912863a
Cext_40 n_127 VPWR 70.0244a
Cext_41 n_127 VGND 71.0801a
Cext_42 n_128 s10 4.90318a
Cext_43 n_128 s5 15.1402a
Cext_44 n_128 s6 55.1192a
Cext_45 n_128 vbn 0.204793a
Cext_46 n_128 vbp 25.8468a
Cext_47 n_128 VGND 0.912863a
Cext_48 n_128 VPWR 70.0244a
Cext_49 n_128 VGND 71.0801a
Cext_50 n_129 s10 4.90318a
Cext_51 n_129 s4 15.1402a
Cext_52 n_129 s5 55.1192a
Cext_53 n_129 vbn 0.204793a
Cext_54 n_129 vbp 25.8468a
Cext_55 n_129 VGND 0.912863a
Cext_56 n_129 VPWR 70.0244a
Cext_57 n_129 VGND 71.0801a
Cext_58 n_130 s10 4.90318a
Cext_59 n_130 s6 15.1402a
Cext_60 n_130 s7 55.1192a
Cext_61 n_130 vbn 0.204793a
Cext_62 n_130 vbp 25.6806a
Cext_63 n_130 VGND 0.912863a
Cext_64 n_130 VPWR 70.3666a
Cext_65 n_130 VGND 71.0801a
Cext_66 n_131 s10 4.90318a
Cext_67 n_131 s7 15.1402a
Cext_68 n_131 s8 55.1192a
Cext_69 n_131 vbn 0.204793a
Cext_70 n_131 vbp 25.8468a
Cext_71 n_131 VGND 0.912863a
Cext_72 n_131 VPWR 70.0244a
Cext_73 n_131 VGND 71.0801a
Cext_74 n_132 s10 4.90318a
Cext_75 n_132 s8 15.1402a
Cext_76 n_132 s9 55.1192a
Cext_77 n_132 vbn 0.204793a
Cext_78 n_132 vbp 25.8468a
Cext_79 n_132 VGND 0.912863a
Cext_80 n_132 VPWR 70.0244a
Cext_81 n_132 VGND 71.0801a
Cext_82 n_133 s10 60.0027a
Cext_83 n_133 s9 15.1402a
Cext_84 n_133 vbp 26.1729a
Cext_85 n_133 VGND 0.907499a
Cext_86 n_133 VPWR 72.6623a
Cext_87 n_133 VGND 71.0801a
Cext_88 n_67 s10 39.0833a
Cext_89 n_67 s9 22.5715a
Cext_90 n_67 vbn 12.9857a
Cext_91 n_67 vbp 18.2475a
Cext_92 n_67 VGND 82.3152a
Cext_93 n_67 VGND 32.6825a
Cext_94 n_68 n_I1005 64.9264a
Cext_95 n_68 enable 9.41952a
Cext_96 n_68 vbn 16.4473a
Cext_97 n_68 vbp 0.144348a
Cext_98 n_68 VGND 86.0631a
Cext_99 n_68 VPWR 0.107675a
Cext_100 n_68 VGND 48.6973a
Cext_101 n_69 s8 22.5715a
Cext_102 n_69 s9 39.0833a
Cext_103 n_69 vbn 14.0739a
Cext_104 n_69 vbp 0.334631a
Cext_105 n_69 VGND 83.232a
Cext_106 n_69 VGND 32.6825a
Cext_107 n_70 s7 22.5715a
Cext_108 n_70 s8 39.0833a
Cext_109 n_70 vbn 14.0739a
Cext_110 n_70 VGND 83.232a
Cext_111 n_70 VGND 32.6825a
Cext_112 n_71 s0 22.5715a
Cext_113 n_71 s1 39.0833a
Cext_114 n_71 vbn 14.0739a
Cext_115 n_71 VGND 83.232a
Cext_116 n_71 VGND 32.7723a
Cext_117 n_72 s6 22.4762a
Cext_118 n_72 s7 39.0833a
Cext_119 n_72 vbn 14.0739a
Cext_120 n_72 VGND 83.9332a
Cext_121 n_72 VGND 32.6825a
Cext_122 n_73 s5 22.5715a
Cext_123 n_73 s6 39.0833a
Cext_124 n_73 vbn 14.0739a
Cext_125 n_73 VGND 83.232a
Cext_126 n_73 VGND 32.6825a
Cext_127 n_74 s4 22.5715a
Cext_128 n_74 s5 39.0833a
Cext_129 n_74 vbn 14.0739a
Cext_130 n_74 VGND 83.232a
Cext_131 n_74 VGND 32.6825a
Cext_132 n_75 s1 22.5715a
Cext_133 n_75 s2 39.0833a
Cext_134 n_75 vbn 14.0739a
Cext_135 n_75 VGND 83.232a
Cext_136 n_75 VGND 32.6825a
Cext_137 n_76 s3 22.5715a
Cext_138 n_76 s4 39.0833a
Cext_139 n_76 vbn 14.0739a
Cext_140 n_76 VGND 83.232a
Cext_141 n_76 VGND 32.6825a
Cext_142 n_77 s2 22.5715a
Cext_143 n_77 s3 39.0833a
Cext_144 n_77 vbn 14.0739a
Cext_145 n_77 VGND 85.2414a
Cext_146 n_77 VGND 32.6825a
Cext_147 n_I1005 enable 5.91922a
Cext_148 n_I1005 s0 64.2969a
Cext_149 n_I1005 s10 5.91922a
Cext_150 n_I1005 vbn 0.655726a
Cext_151 n_I1005 VGND 14.7347a
Cext_152 n_I1005 VPWR 0.123057a
Cext_153 n_I1005 VGND 12.2928a
Cext_154 b1 clk_out 213.583a
Cext_155 b1 s10 275.475a
Cext_156 b1 vbp 8.86504a
Cext_157 clk_out s10 1.73287a
Cext_158 clk_out s8 0.130333a
Cext_159 clk_out s9 0.13783a
Cext_160 clk_out vbn 1.11368a
Cext_161 clk_out vbp 8.41073a
Cext_162 code[0] code[1] 3.81552f
Cext_163 code[0] code[2] 34.6197a
Cext_164 code[0] code[3] 34.897a
Cext_165 code[0] code[4] 69.5166a
Cext_166 code[0] code[5] 139.033a
Cext_167 code[0] code[6] 278.067a
Cext_168 code[0] code[7] 556.133a
Cext_169 code[0] enable 13.4179a
Cext_170 code[0] vbp 426.112a
Cext_171 code[1] code[2] 3.37646f
Cext_172 code[1] code[3] 18.3064a
Cext_173 code[1] code[4] 36.6128a
Cext_174 code[1] code[5] 73.2255a
Cext_175 code[1] code[6] 146.451a
Cext_176 code[1] code[7] 293.623a
Cext_177 code[1] enable 21.7603a
Cext_178 code[1] vbp 699.357a
Cext_179 code[2] code[3] 5.49861f
Cext_180 code[2] code[4] 36.3537a
Cext_181 code[2] code[5] 72.7074a
Cext_182 code[2] code[6] 145.415a
Cext_183 code[2] code[7] 291.55a
Cext_184 code[2] enable 6.48522a
Cext_185 code[2] vbn 14.0185a
Cext_186 code[2] vbp 1.42547f
Cext_187 code[3] code[4] 4.52549f
Cext_188 code[3] code[5] 72.7074a
Cext_189 code[3] code[6] 145.415a
Cext_190 code[3] code[7] 291.55a
Cext_191 code[3] enable 19.9332a
Cext_192 code[3] s0 0.845591a
Cext_193 code[3] s1 0.969857a
Cext_194 code[3] s10 0.324778a
Cext_195 code[3] s2 0.969857a
Cext_196 code[3] s3 0.969857a
Cext_197 code[3] s4 0.969857a
Cext_198 code[3] s5 0.969857a
Cext_199 code[3] s6 0.969857a
Cext_200 code[3] s7 0.969857a
Cext_201 code[3] s8 0.969857a
Cext_202 code[3] s9 0.124266a
Cext_203 code[3] vbn 37.7485a
Cext_204 code[3] vbp 2.82733f
Cext_205 code[4] code[5] 4.4125f
Cext_206 code[4] code[6] 145.415a
Cext_207 code[4] code[7] 291.55a
Cext_208 code[4] enable 31.8533a
Cext_209 code[4] vbp 5.58092f
Cext_210 code[5] code[6] 4.1716f
Cext_211 code[5] code[7] 291.55a
Cext_212 code[5] enable 87.7799a
Cext_213 code[5] vbp 11.1628f
Cext_214 code[6] code[7] 3.67563f
Cext_215 code[6] enable 279.41a
Cext_216 code[6] vbp 22.3257f
Cext_217 code[7] enable 1.62863f
Cext_218 code[7] vbp 44.6294f
Cext_219 enable s0 92.9916a
Cext_220 enable s10 193.456a
Cext_221 enable vbn 67.5341a
Cext_222 enable vbp 2.48807f
Cext_223 s0 s1 135.542a
Cext_224 s0 s10 124.35a
Cext_225 s0 vbn 230.397a
Cext_226 s0 vbp 109.071a
Cext_227 s1 s10 31.8462a
Cext_228 s1 s2 142.784a
Cext_229 s1 vbn 216.419a
Cext_230 s1 vbp 121.15a
Cext_231 s10 s2 27.8201a
Cext_232 s10 s3 27.8645a
Cext_233 s10 s4 27.8645a
Cext_234 s10 s5 27.8645a
Cext_235 s10 s6 27.7955a
Cext_236 s10 s7 27.8596a
Cext_237 s10 s8 27.8645a
Cext_238 s10 s9 229.733a
Cext_239 s10 vbn 47.631a
Cext_240 s10 vbp 3.75793f
Cext_241 s2 s3 142.784a
Cext_242 s2 vbn 216.419a
Cext_243 s2 vbp 121.067a
Cext_244 s3 s4 142.784a
Cext_245 s3 vbn 216.419a
Cext_246 s3 vbp 121.416a
Cext_247 s4 s5 142.784a
Cext_248 s4 vbn 216.419a
Cext_249 s4 vbp 121.416a
Cext_250 s5 s6 142.784a
Cext_251 s5 vbn 216.419a
Cext_252 s5 vbp 121.416a
Cext_253 s6 s7 142.748a
Cext_254 s6 vbn 216.095a
Cext_255 s6 vbp 121.424a
Cext_256 s7 s8 142.748a
Cext_257 s7 vbn 216.376a
Cext_258 s7 vbp 121.847a
Cext_259 s8 s9 142.748a
Cext_260 s8 vbn 216.419a
Cext_261 s8 vbp 124.244a
Cext_262 s9 vbn 173.086a
Cext_263 s9 vbp 141.127a
Cext_264 vbn vbp 7.7347f
Cext_265 VGND b1 160.683a
Cext_266 VGND clk_out 407.411a
Cext_267 VGND code[0] 1.1599f
Cext_268 VGND code[1] 978.041a
Cext_269 VGND code[2] 1.47504f
Cext_270 VGND code[3] 2.76026f
Cext_271 VGND code[4] 5.11581f
Cext_272 VGND code[5] 9.67284f
Cext_273 VGND code[6] 18.9192f
Cext_274 VGND code[7] 37.9115f
Cext_275 VGND enable 455.269a
Cext_276 VGND s0 97.1975a
Cext_277 VGND s1 90.919a
Cext_278 VGND s10 107.069a
Cext_279 VGND s2 92.5257a
Cext_280 VGND s3 90.7772a
Cext_281 VGND s4 90.919a
Cext_282 VGND s5 90.919a
Cext_283 VGND s6 97.1117a
Cext_284 VGND s7 100.011a
Cext_285 VGND s8 90.919a
Cext_286 VGND s9 88.4873a
Cext_287 VGND vbn 1.24245f
Cext_288 VGND vbp 95.45f
Cext_289 VGND VPWR 3.24064f
Cext_290 VGND VGND 68.4477f
Cext_291 VPWR b1 125.786a
Cext_292 VPWR clk_out 249.958a
Cext_293 VPWR code[0] 59.5352a
Cext_294 VPWR code[1] 39.7505a
Cext_295 VPWR code[2] 1.70794a
Cext_296 VPWR enable 654.652a
Cext_297 VPWR s0 15.165a
Cext_298 VPWR s1 48.4258a
Cext_299 VPWR s10 295.534a
Cext_300 VPWR s2 48.2908a
Cext_301 VPWR s3 48.4258a
Cext_302 VPWR s4 48.4258a
Cext_303 VPWR s5 48.4258a
Cext_304 VPWR s6 51.1485a
Cext_305 VPWR s7 51.3466a
Cext_306 VPWR s8 48.4258a
Cext_307 VPWR s9 47.8534a
Cext_308 VPWR vbn 153.546a
Cext_309 VPWR vbp 5.24451f
Cext_310 VPWR VGND 18.745f
Cext_311 VGND b1 856.979a
Cext_312 VGND clk_out 678.599a
Cext_313 VGND code[0] 1.9296f
Cext_314 VGND code[1] 2.73911f
Cext_315 VGND code[2] 4.58615f
Cext_316 VGND code[3] 9.08909f
Cext_317 VGND code[4] 15.1639f
Cext_318 VGND code[5] 29.8722f
Cext_319 VGND code[6] 59.3723f
Cext_320 VGND code[7] 120.135f
Cext_321 VGND enable 4.79984f
Cext_322 VGND s0 760.019a
Cext_323 VGND s1 738.564a
Cext_324 VGND s10 1.83226f
Cext_325 VGND s2 736.105a
Cext_326 VGND s3 736.105a
Cext_327 VGND s4 736.105a
Cext_328 VGND s5 736.105a
Cext_329 VGND s6 736.071a
Cext_330 VGND s7 735.881a
Cext_331 VGND s8 735.754a
Cext_332 VGND s9 732.77a
Cext_333 VGND vbn 5.4132f
Cext_334 VGND vbp 33.0044f
.ends tt_analog_ring
