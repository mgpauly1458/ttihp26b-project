* code[7] bus RC settling through a 500 ohm driver
.lib /foss/pdks/ihp-sg13g2/libs.tech/ngspice/models/cornerMOSlv.lib mos_tt
.option temp=27
.include /work/analog/out/pex/tt_analog_ring.pex.spice
Vdd VPWR 0 1.2
Vc0 code[0] 0 0
Vc1 code[1] 0 0
Vc2 code[2] 0 0
Vc3 code[3] 0 0
Vc4 code[4] 0 0
Vc5 code[5] 0 0
Vc6 code[6] 0 0
Vdrv drv 0 pulse(0 1.2 1n 0.05n)
Rdrv drv code[7] 500
Ven enable 0 0
Xdut code[0] code[1] code[2] code[3] code[4] code[5] code[6] code[7] enable clk_out VPWR 0 tt_analog_ring
Cload clk_out 0 15f
.control
tran 5p 40n
meas tran t10 when v(code[7])=0.12 rise=1
meas tran t90 when v(code[7])=1.08 rise=1
let trc = t90 - t10
echo "trc=$&trc"
.endc
.end
