* environment: xcode {'bit': 7} code 255
.lib /foss/pdks/ihp-sg13g2/libs.tech/ngspice/models/cornerMOSlv.lib mos_tt
.option temp=27
.include /work/analog/out/pex/tt_analog_ring.pex.spice
Vdd VPWR 0 dc 1.2
Vc0 code[0] VPWR 0
Vc1 code[1] VPWR 0
Vc2 code[2] VPWR 0
Vc3 code[3] VPWR 0
Vc4 code[4] VPWR 0
Vc5 code[5] VPWR 0
Vc6 code[6] VPWR 0
Vc7 c7s VPWR 0
Rd7 c7s code[7] 500
Cx7 ag code[7] 20f
Ven enable VPWR 0
Xdut code[0] code[1] code[2] code[3] code[4] code[5] code[6] code[7] enable clk_out VPWR 0 tt_analog_ring
Cload clk_out 0 15f
Vag ag 0 pulse(0 1.2 0 0.2n 0.2n 9.8n 20n)
.control
tran 2.008e-11 6.024e-07
let ts = 6.024e-08
meas tran vmin_out min v(clk_out) from=$&ts
meas tran vmax_out max v(clk_out) from=$&ts
meas tran vg_min min v(code[7]) from=$&ts
meas tran vg_max max v(code[7]) from=$&ts

wrdata clk.txt v(clk_out)
.endc
.end
