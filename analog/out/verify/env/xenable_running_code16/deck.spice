* environment: xenable_running {} code 16
.lib /foss/pdks/ihp-sg13g2/libs.tech/ngspice/models/cornerMOSlv.lib mos_tt
.option temp=27
.include /work/analog/spice/tt_analog_ring.spice
Vdd VPWR 0 dc 1.2
Vc0 code[0] 0 0
Vc1 code[1] 0 0
Vc2 code[2] 0 0
Vc3 code[3] 0 0
Vc4 code[4] VPWR 0
Vc5 code[5] 0 0
Vc6 code[6] 0 0
Vc7 code[7] 0 0
Ven ens VPWR 0
Rden ens enable 500
Cxe ag enable 20f
Xdut code[0] code[1] code[2] code[3] code[4] code[5] code[6] code[7] enable clk_out VPWR 0 tt_analog_ring
Cload clk_out 0 15f
Vag ag 0 pulse(0 1.2 0 0.2n 0.2n 9.8n 20n)
.control
tran 5e-11 5.42e-06
let ts = 5.42e-07
meas tran vmin_out min v(clk_out) from=$&ts
meas tran vmax_out max v(clk_out) from=$&ts

meas tran ven_max max v(enable) from=$&ts
meas tran ven_min min v(enable) from=$&ts
wrdata clk.txt v(clk_out)
.endc
.end
