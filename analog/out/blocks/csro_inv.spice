** sch_path: /work/analog/xschem/csro_inv.sch
**.subckt csro_inv in out VPWR VGND
*.ipin in
*.opin out
*.iopin VPWR
*.iopin VGND
XMBP out in VPWR VPWR sg13_lv_pmos w=0.5u l=0.13u ng=1 m=1 mm_ok=1
XMBN out in VGND VGND sg13_lv_nmos w=0.3u l=0.13u ng=1 m=1 mm_ok=1
**.ends
.end
